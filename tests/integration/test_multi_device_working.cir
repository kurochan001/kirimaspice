* Multi-Device Integration Test (WORKING version)
* BJT with emitter directly grounded

* Include manufacturer models
.INCLUDE ../models/2N3904.lib

* Power supply
Vcc vcc 0 DC 12

* Input voltage
Vin in 0 DC 5

* Input resistor
Rin in base 10k

* Base-emitter bias resistor
Rbe base 0 100k

* Transistor amplifier (common emitter, direct ground)
Q1 collector base 0 2N3904

* Collector resistor
Rc vcc collector 4.7k

* Analysis
.DC Vin 0 10 0.5

.end
