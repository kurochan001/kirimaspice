* GND is an ordinary node at the top level: a 1k/3k divider puts it at 0.75 V
V1 a 0 DC 1
R1 a GND 1k
R2 GND 0 3k
.op
.end
