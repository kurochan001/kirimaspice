* RC low-pass step (DC source)
V1 in 0 DC 5
R1 in out 1k
C1 out 0 1u
.tran 0.1m 5m
.save tran v(out)
.end
