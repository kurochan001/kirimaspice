* 2-Stage BJT Common-Emitter Amplifier AC Analysis
* Two cascaded CE stages for high gain

.model Q2N2222 NPN BF=100 IS=1e-14

* Power supply
Vcc vcc 0 DC 12

* Input signal (AC only)
Vin in 0 DC 0 AC 0.01

* Stage 1: Common-emitter amplifier
Cin in base1 10u
R1_1 vcc base1 100k
R2_1 base1 0 22k
Rc1 vcc c1 4.7k
Re1 e1 0 1k
Ce1 e1 0 100u
Q1 c1 base1 e1 Q2N2222

* Stage 2: Common-emitter amplifier
Cc c1 base2 10u
R1_2 vcc base2 100k
R2_2 base2 0 22k
Rc2 vcc c2 4.7k
Re2 e2 0 1k
Ce2 e2 0 100u
Q2 c2 base2 e2 Q2N2222

* Output
Cout c2 out 10u
Rload out 0 10k

.ac dec 20 10 1000000

.control
ac dec 20 10 1000000
wrdata bjt_2stage_amplifier_ac_ngspice.dat v(out)
.endc
.end
