* 13x13 Resistor Mesh DC Analysis for validation
* Circuit: Vin at n_0_0, GND via Rload at n_12_12
* Total devices: ~313 resistors

Vin n_0_0 0 DC 1

* Row 0
Rh_0_0 n_0_0 n_0_1 1k
Rh_0_1 n_0_1 n_0_2 1k
Rh_0_2 n_0_2 n_0_3 1k
Rh_0_3 n_0_3 n_0_4 1k
Rh_0_4 n_0_4 n_0_5 1k
Rh_0_5 n_0_5 n_0_6 1k
Rh_0_6 n_0_6 n_0_7 1k
Rh_0_7 n_0_7 n_0_8 1k
Rh_0_8 n_0_8 n_0_9 1k
Rh_0_9 n_0_9 n_0_10 1k
Rh_0_10 n_0_10 n_0_11 1k
Rh_0_11 n_0_11 n_0_12 1k

* Row 1
Rh_1_0 n_1_0 n_1_1 1k
Rh_1_1 n_1_1 n_1_2 1k
Rh_1_2 n_1_2 n_1_3 1k
Rh_1_3 n_1_3 n_1_4 1k
Rh_1_4 n_1_4 n_1_5 1k
Rh_1_5 n_1_5 n_1_6 1k
Rh_1_6 n_1_6 n_1_7 1k
Rh_1_7 n_1_7 n_1_8 1k
Rh_1_8 n_1_8 n_1_9 1k
Rh_1_9 n_1_9 n_1_10 1k
Rh_1_10 n_1_10 n_1_11 1k
Rh_1_11 n_1_11 n_1_12 1k

* Row 2
Rh_2_0 n_2_0 n_2_1 1k
Rh_2_1 n_2_1 n_2_2 1k
Rh_2_2 n_2_2 n_2_3 1k
Rh_2_3 n_2_3 n_2_4 1k
Rh_2_4 n_2_4 n_2_5 1k
Rh_2_5 n_2_5 n_2_6 1k
Rh_2_6 n_2_6 n_2_7 1k
Rh_2_7 n_2_7 n_2_8 1k
Rh_2_8 n_2_8 n_2_9 1k
Rh_2_9 n_2_9 n_2_10 1k
Rh_2_10 n_2_10 n_2_11 1k
Rh_2_11 n_2_11 n_2_12 1k

* Row 3
Rh_3_0 n_3_0 n_3_1 1k
Rh_3_1 n_3_1 n_3_2 1k
Rh_3_2 n_3_2 n_3_3 1k
Rh_3_3 n_3_3 n_3_4 1k
Rh_3_4 n_3_4 n_3_5 1k
Rh_3_5 n_3_5 n_3_6 1k
Rh_3_6 n_3_6 n_3_7 1k
Rh_3_7 n_3_7 n_3_8 1k
Rh_3_8 n_3_8 n_3_9 1k
Rh_3_9 n_3_9 n_3_10 1k
Rh_3_10 n_3_10 n_3_11 1k
Rh_3_11 n_3_11 n_3_12 1k

* Row 4
Rh_4_0 n_4_0 n_4_1 1k
Rh_4_1 n_4_1 n_4_2 1k
Rh_4_2 n_4_2 n_4_3 1k
Rh_4_3 n_4_3 n_4_4 1k
Rh_4_4 n_4_4 n_4_5 1k
Rh_4_5 n_4_5 n_4_6 1k
Rh_4_6 n_4_6 n_4_7 1k
Rh_4_7 n_4_7 n_4_8 1k
Rh_4_8 n_4_8 n_4_9 1k
Rh_4_9 n_4_9 n_4_10 1k
Rh_4_10 n_4_10 n_4_11 1k
Rh_4_11 n_4_11 n_4_12 1k

* Row 5
Rh_5_0 n_5_0 n_5_1 1k
Rh_5_1 n_5_1 n_5_2 1k
Rh_5_2 n_5_2 n_5_3 1k
Rh_5_3 n_5_3 n_5_4 1k
Rh_5_4 n_5_4 n_5_5 1k
Rh_5_5 n_5_5 n_5_6 1k
Rh_5_6 n_5_6 n_5_7 1k
Rh_5_7 n_5_7 n_5_8 1k
Rh_5_8 n_5_8 n_5_9 1k
Rh_5_9 n_5_9 n_5_10 1k
Rh_5_10 n_5_10 n_5_11 1k
Rh_5_11 n_5_11 n_5_12 1k

* Row 6
Rh_6_0 n_6_0 n_6_1 1k
Rh_6_1 n_6_1 n_6_2 1k
Rh_6_2 n_6_2 n_6_3 1k
Rh_6_3 n_6_3 n_6_4 1k
Rh_6_4 n_6_4 n_6_5 1k
Rh_6_5 n_6_5 n_6_6 1k
Rh_6_6 n_6_6 n_6_7 1k
Rh_6_7 n_6_7 n_6_8 1k
Rh_6_8 n_6_8 n_6_9 1k
Rh_6_9 n_6_9 n_6_10 1k
Rh_6_10 n_6_10 n_6_11 1k
Rh_6_11 n_6_11 n_6_12 1k

* Row 7
Rh_7_0 n_7_0 n_7_1 1k
Rh_7_1 n_7_1 n_7_2 1k
Rh_7_2 n_7_2 n_7_3 1k
Rh_7_3 n_7_3 n_7_4 1k
Rh_7_4 n_7_4 n_7_5 1k
Rh_7_5 n_7_5 n_7_6 1k
Rh_7_6 n_7_6 n_7_7 1k
Rh_7_7 n_7_7 n_7_8 1k
Rh_7_8 n_7_8 n_7_9 1k
Rh_7_9 n_7_9 n_7_10 1k
Rh_7_10 n_7_10 n_7_11 1k
Rh_7_11 n_7_11 n_7_12 1k

* Row 8
Rh_8_0 n_8_0 n_8_1 1k
Rh_8_1 n_8_1 n_8_2 1k
Rh_8_2 n_8_2 n_8_3 1k
Rh_8_3 n_8_3 n_8_4 1k
Rh_8_4 n_8_4 n_8_5 1k
Rh_8_5 n_8_5 n_8_6 1k
Rh_8_6 n_8_6 n_8_7 1k
Rh_8_7 n_8_7 n_8_8 1k
Rh_8_8 n_8_8 n_8_9 1k
Rh_8_9 n_8_9 n_8_10 1k
Rh_8_10 n_8_10 n_8_11 1k
Rh_8_11 n_8_11 n_8_12 1k

* Row 9
Rh_9_0 n_9_0 n_9_1 1k
Rh_9_1 n_9_1 n_9_2 1k
Rh_9_2 n_9_2 n_9_3 1k
Rh_9_3 n_9_3 n_9_4 1k
Rh_9_4 n_9_4 n_9_5 1k
Rh_9_5 n_9_5 n_9_6 1k
Rh_9_6 n_9_6 n_9_7 1k
Rh_9_7 n_9_7 n_9_8 1k
Rh_9_8 n_9_8 n_9_9 1k
Rh_9_9 n_9_9 n_9_10 1k
Rh_9_10 n_9_10 n_9_11 1k
Rh_9_11 n_9_11 n_9_12 1k

* Row 10
Rh_10_0 n_10_0 n_10_1 1k
Rh_10_1 n_10_1 n_10_2 1k
Rh_10_2 n_10_2 n_10_3 1k
Rh_10_3 n_10_3 n_10_4 1k
Rh_10_4 n_10_4 n_10_5 1k
Rh_10_5 n_10_5 n_10_6 1k
Rh_10_6 n_10_6 n_10_7 1k
Rh_10_7 n_10_7 n_10_8 1k
Rh_10_8 n_10_8 n_10_9 1k
Rh_10_9 n_10_9 n_10_10 1k
Rh_10_10 n_10_10 n_10_11 1k
Rh_10_11 n_10_11 n_10_12 1k

* Row 11
Rh_11_0 n_11_0 n_11_1 1k
Rh_11_1 n_11_1 n_11_2 1k
Rh_11_2 n_11_2 n_11_3 1k
Rh_11_3 n_11_3 n_11_4 1k
Rh_11_4 n_11_4 n_11_5 1k
Rh_11_5 n_11_5 n_11_6 1k
Rh_11_6 n_11_6 n_11_7 1k
Rh_11_7 n_11_7 n_11_8 1k
Rh_11_8 n_11_8 n_11_9 1k
Rh_11_9 n_11_9 n_11_10 1k
Rh_11_10 n_11_10 n_11_11 1k
Rh_11_11 n_11_11 n_11_12 1k

* Row 12
Rh_12_0 n_12_0 n_12_1 1k
Rh_12_1 n_12_1 n_12_2 1k
Rh_12_2 n_12_2 n_12_3 1k
Rh_12_3 n_12_3 n_12_4 1k
Rh_12_4 n_12_4 n_12_5 1k
Rh_12_5 n_12_5 n_12_6 1k
Rh_12_6 n_12_6 n_12_7 1k
Rh_12_7 n_12_7 n_12_8 1k
Rh_12_8 n_12_8 n_12_9 1k
Rh_12_9 n_12_9 n_12_10 1k
Rh_12_10 n_12_10 n_12_11 1k
Rh_12_11 n_12_11 n_12_12 1k

* Vertical resistors (Column 0)
Rv_0_0 n_0_0 n_1_0 1k
Rv_1_0 n_1_0 n_2_0 1k
Rv_2_0 n_2_0 n_3_0 1k
Rv_3_0 n_3_0 n_4_0 1k
Rv_4_0 n_4_0 n_5_0 1k
Rv_5_0 n_5_0 n_6_0 1k
Rv_6_0 n_6_0 n_7_0 1k
Rv_7_0 n_7_0 n_8_0 1k
Rv_8_0 n_8_0 n_9_0 1k
Rv_9_0 n_9_0 n_10_0 1k
Rv_10_0 n_10_0 n_11_0 1k
Rv_11_0 n_11_0 n_12_0 1k

* Vertical resistors (Column 1)
Rv_0_1 n_0_1 n_1_1 1k
Rv_1_1 n_1_1 n_2_1 1k
Rv_2_1 n_2_1 n_3_1 1k
Rv_3_1 n_3_1 n_4_1 1k
Rv_4_1 n_4_1 n_5_1 1k
Rv_5_1 n_5_1 n_6_1 1k
Rv_6_1 n_6_1 n_7_1 1k
Rv_7_1 n_7_1 n_8_1 1k
Rv_8_1 n_8_1 n_9_1 1k
Rv_9_1 n_9_1 n_10_1 1k
Rv_10_1 n_10_1 n_11_1 1k
Rv_11_1 n_11_1 n_12_1 1k

* Vertical resistors (Column 2)
Rv_0_2 n_0_2 n_1_2 1k
Rv_1_2 n_1_2 n_2_2 1k
Rv_2_2 n_2_2 n_3_2 1k
Rv_3_2 n_3_2 n_4_2 1k
Rv_4_2 n_4_2 n_5_2 1k
Rv_5_2 n_5_2 n_6_2 1k
Rv_6_2 n_6_2 n_7_2 1k
Rv_7_2 n_7_2 n_8_2 1k
Rv_8_2 n_8_2 n_9_2 1k
Rv_9_2 n_9_2 n_10_2 1k
Rv_10_2 n_10_2 n_11_2 1k
Rv_11_2 n_11_2 n_12_2 1k

* Vertical resistors (Column 3)
Rv_0_3 n_0_3 n_1_3 1k
Rv_1_3 n_1_3 n_2_3 1k
Rv_2_3 n_2_3 n_3_3 1k
Rv_3_3 n_3_3 n_4_3 1k
Rv_4_3 n_4_3 n_5_3 1k
Rv_5_3 n_5_3 n_6_3 1k
Rv_6_3 n_6_3 n_7_3 1k
Rv_7_3 n_7_3 n_8_3 1k
Rv_8_3 n_8_3 n_9_3 1k
Rv_9_3 n_9_3 n_10_3 1k
Rv_10_3 n_10_3 n_11_3 1k
Rv_11_3 n_11_3 n_12_3 1k

* Vertical resistors (Column 4)
Rv_0_4 n_0_4 n_1_4 1k
Rv_1_4 n_1_4 n_2_4 1k
Rv_2_4 n_2_4 n_3_4 1k
Rv_3_4 n_3_4 n_4_4 1k
Rv_4_4 n_4_4 n_5_4 1k
Rv_5_4 n_5_4 n_6_4 1k
Rv_6_4 n_6_4 n_7_4 1k
Rv_7_4 n_7_4 n_8_4 1k
Rv_8_4 n_8_4 n_9_4 1k
Rv_9_4 n_9_4 n_10_4 1k
Rv_10_4 n_10_4 n_11_4 1k
Rv_11_4 n_11_4 n_12_4 1k

* Vertical resistors (Column 5)
Rv_0_5 n_0_5 n_1_5 1k
Rv_1_5 n_1_5 n_2_5 1k
Rv_2_5 n_2_5 n_3_5 1k
Rv_3_5 n_3_5 n_4_5 1k
Rv_4_5 n_4_5 n_5_5 1k
Rv_5_5 n_5_5 n_6_5 1k
Rv_6_5 n_6_5 n_7_5 1k
Rv_7_5 n_7_5 n_8_5 1k
Rv_8_5 n_8_5 n_9_5 1k
Rv_9_5 n_9_5 n_10_5 1k
Rv_10_5 n_10_5 n_11_5 1k
Rv_11_5 n_11_5 n_12_5 1k

* Vertical resistors (Column 6)
Rv_0_6 n_0_6 n_1_6 1k
Rv_1_6 n_1_6 n_2_6 1k
Rv_2_6 n_2_6 n_3_6 1k
Rv_3_6 n_3_6 n_4_6 1k
Rv_4_6 n_4_6 n_5_6 1k
Rv_5_6 n_5_6 n_6_6 1k
Rv_6_6 n_6_6 n_7_6 1k
Rv_7_6 n_7_6 n_8_6 1k
Rv_8_6 n_8_6 n_9_6 1k
Rv_9_6 n_9_6 n_10_6 1k
Rv_10_6 n_10_6 n_11_6 1k
Rv_11_6 n_11_6 n_12_6 1k

* Vertical resistors (Column 7)
Rv_0_7 n_0_7 n_1_7 1k
Rv_1_7 n_1_7 n_2_7 1k
Rv_2_7 n_2_7 n_3_7 1k
Rv_3_7 n_3_7 n_4_7 1k
Rv_4_7 n_4_7 n_5_7 1k
Rv_5_7 n_5_7 n_6_7 1k
Rv_6_7 n_6_7 n_7_7 1k
Rv_7_7 n_7_7 n_8_7 1k
Rv_8_7 n_8_7 n_9_7 1k
Rv_9_7 n_9_7 n_10_7 1k
Rv_10_7 n_10_7 n_11_7 1k
Rv_11_7 n_11_7 n_12_7 1k

* Vertical resistors (Column 8)
Rv_0_8 n_0_8 n_1_8 1k
Rv_1_8 n_1_8 n_2_8 1k
Rv_2_8 n_2_8 n_3_8 1k
Rv_3_8 n_3_8 n_4_8 1k
Rv_4_8 n_4_8 n_5_8 1k
Rv_5_8 n_5_8 n_6_8 1k
Rv_6_8 n_6_8 n_7_8 1k
Rv_7_8 n_7_8 n_8_8 1k
Rv_8_8 n_8_8 n_9_8 1k
Rv_9_8 n_9_8 n_10_8 1k
Rv_10_8 n_10_8 n_11_8 1k
Rv_11_8 n_11_8 n_12_8 1k

* Vertical resistors (Column 9)
Rv_0_9 n_0_9 n_1_9 1k
Rv_1_9 n_1_9 n_2_9 1k
Rv_2_9 n_2_9 n_3_9 1k
Rv_3_9 n_3_9 n_4_9 1k
Rv_4_9 n_4_9 n_5_9 1k
Rv_5_9 n_5_9 n_6_9 1k
Rv_6_9 n_6_9 n_7_9 1k
Rv_7_9 n_7_9 n_8_9 1k
Rv_8_9 n_8_9 n_9_9 1k
Rv_9_9 n_9_9 n_10_9 1k
Rv_10_9 n_10_9 n_11_9 1k
Rv_11_9 n_11_9 n_12_9 1k

* Vertical resistors (Column 10)
Rv_0_10 n_0_10 n_1_10 1k
Rv_1_10 n_1_10 n_2_10 1k
Rv_2_10 n_2_10 n_3_10 1k
Rv_3_10 n_3_10 n_4_10 1k
Rv_4_10 n_4_10 n_5_10 1k
Rv_5_10 n_5_10 n_6_10 1k
Rv_6_10 n_6_10 n_7_10 1k
Rv_7_10 n_7_10 n_8_10 1k
Rv_8_10 n_8_10 n_9_10 1k
Rv_9_10 n_9_10 n_10_10 1k
Rv_10_10 n_10_10 n_11_10 1k
Rv_11_10 n_11_10 n_12_10 1k

* Vertical resistors (Column 11)
Rv_0_11 n_0_11 n_1_11 1k
Rv_1_11 n_1_11 n_2_11 1k
Rv_2_11 n_2_11 n_3_11 1k
Rv_3_11 n_3_11 n_4_11 1k
Rv_4_11 n_4_11 n_5_11 1k
Rv_5_11 n_5_11 n_6_11 1k
Rv_6_11 n_6_11 n_7_11 1k
Rv_7_11 n_7_11 n_8_11 1k
Rv_8_11 n_8_11 n_9_11 1k
Rv_9_11 n_9_11 n_10_11 1k
Rv_10_11 n_10_11 n_11_11 1k
Rv_11_11 n_11_11 n_12_11 1k

* Vertical resistors (Column 12)
Rv_0_12 n_0_12 n_1_12 1k
Rv_1_12 n_1_12 n_2_12 1k
Rv_2_12 n_2_12 n_3_12 1k
Rv_3_12 n_3_12 n_4_12 1k
Rv_4_12 n_4_12 n_5_12 1k
Rv_5_12 n_5_12 n_6_12 1k
Rv_6_12 n_6_12 n_7_12 1k
Rv_7_12 n_7_12 n_8_12 1k
Rv_8_12 n_8_12 n_9_12 1k
Rv_9_12 n_9_12 n_10_12 1k
Rv_10_12 n_10_12 n_11_12 1k
Rv_11_12 n_11_12 n_12_12 1k

* Load resistor at bottom-right corner
Rload n_12_12 0 1k

.op
.control
op
print all > resistor_mesh_13x13_dc_raw.txt
.endc
.end
