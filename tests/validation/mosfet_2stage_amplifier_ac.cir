* 2-Stage MOSFET Common-Source Amplifier AC Analysis
* Two cascaded CS stages with proper DC bias

.model NMOS1 NMOS LEVEL=1 KP=2e-5 VTO=0.7

* Power supply
VDD vdd 0 DC 10

* Input signal (AC only)
Vin in 0 DC 0 AC 0.01

* Stage 1: Common-source amplifier with self-bias
Cin in gate1 10u
Rg1a vdd gate1 1MEG
Rg1b gate1 0 470k
Rd1 vdd d1 10k
Rs1 s1 0 2k
Cs1 s1 0 100u
M1 d1 gate1 s1 s1 NMOS1 W=10u L=1u

* Stage 2: Common-source amplifier with self-bias
Cc d1 gate2 10u
Rg2a vdd gate2 1MEG
Rg2b gate2 0 470k
Rd2 vdd d2 10k
Rs2 s2 0 2k
Cs2 s2 0 100u
M2 d2 gate2 s2 s2 NMOS1 W=10u L=1u

* Output
Cout d2 out 10u
Rload out 0 10k

.ac dec 20 10 1000000

.control
ac dec 20 10 1000000
wrdata mosfet_2stage_amplifier_ac_ngspice.dat v(out)
.endc
.end
