* 39x39 Resistor Mesh DC Analysis for validation
* Circuit: Vin at n_0_0, GND via Rload at n_38_38
* Total devices: ~2965 resistors

Vin n_0_0 0 DC 1

* Row 0
Rh_0_0 n_0_0 n_0_1 1k
Rh_0_1 n_0_1 n_0_2 1k
Rh_0_2 n_0_2 n_0_3 1k
Rh_0_3 n_0_3 n_0_4 1k
Rh_0_4 n_0_4 n_0_5 1k
Rh_0_5 n_0_5 n_0_6 1k
Rh_0_6 n_0_6 n_0_7 1k
Rh_0_7 n_0_7 n_0_8 1k
Rh_0_8 n_0_8 n_0_9 1k
Rh_0_9 n_0_9 n_0_10 1k
Rh_0_10 n_0_10 n_0_11 1k
Rh_0_11 n_0_11 n_0_12 1k
Rh_0_12 n_0_12 n_0_13 1k
Rh_0_13 n_0_13 n_0_14 1k
Rh_0_14 n_0_14 n_0_15 1k
Rh_0_15 n_0_15 n_0_16 1k
Rh_0_16 n_0_16 n_0_17 1k
Rh_0_17 n_0_17 n_0_18 1k
Rh_0_18 n_0_18 n_0_19 1k
Rh_0_19 n_0_19 n_0_20 1k
Rh_0_20 n_0_20 n_0_21 1k
Rh_0_21 n_0_21 n_0_22 1k
Rh_0_22 n_0_22 n_0_23 1k
Rh_0_23 n_0_23 n_0_24 1k
Rh_0_24 n_0_24 n_0_25 1k
Rh_0_25 n_0_25 n_0_26 1k
Rh_0_26 n_0_26 n_0_27 1k
Rh_0_27 n_0_27 n_0_28 1k
Rh_0_28 n_0_28 n_0_29 1k
Rh_0_29 n_0_29 n_0_30 1k
Rh_0_30 n_0_30 n_0_31 1k
Rh_0_31 n_0_31 n_0_32 1k
Rh_0_32 n_0_32 n_0_33 1k
Rh_0_33 n_0_33 n_0_34 1k
Rh_0_34 n_0_34 n_0_35 1k
Rh_0_35 n_0_35 n_0_36 1k
Rh_0_36 n_0_36 n_0_37 1k
Rh_0_37 n_0_37 n_0_38 1k

* Row 1
Rh_1_0 n_1_0 n_1_1 1k
Rh_1_1 n_1_1 n_1_2 1k
Rh_1_2 n_1_2 n_1_3 1k
Rh_1_3 n_1_3 n_1_4 1k
Rh_1_4 n_1_4 n_1_5 1k
Rh_1_5 n_1_5 n_1_6 1k
Rh_1_6 n_1_6 n_1_7 1k
Rh_1_7 n_1_7 n_1_8 1k
Rh_1_8 n_1_8 n_1_9 1k
Rh_1_9 n_1_9 n_1_10 1k
Rh_1_10 n_1_10 n_1_11 1k
Rh_1_11 n_1_11 n_1_12 1k
Rh_1_12 n_1_12 n_1_13 1k
Rh_1_13 n_1_13 n_1_14 1k
Rh_1_14 n_1_14 n_1_15 1k
Rh_1_15 n_1_15 n_1_16 1k
Rh_1_16 n_1_16 n_1_17 1k
Rh_1_17 n_1_17 n_1_18 1k
Rh_1_18 n_1_18 n_1_19 1k
Rh_1_19 n_1_19 n_1_20 1k
Rh_1_20 n_1_20 n_1_21 1k
Rh_1_21 n_1_21 n_1_22 1k
Rh_1_22 n_1_22 n_1_23 1k
Rh_1_23 n_1_23 n_1_24 1k
Rh_1_24 n_1_24 n_1_25 1k
Rh_1_25 n_1_25 n_1_26 1k
Rh_1_26 n_1_26 n_1_27 1k
Rh_1_27 n_1_27 n_1_28 1k
Rh_1_28 n_1_28 n_1_29 1k
Rh_1_29 n_1_29 n_1_30 1k
Rh_1_30 n_1_30 n_1_31 1k
Rh_1_31 n_1_31 n_1_32 1k
Rh_1_32 n_1_32 n_1_33 1k
Rh_1_33 n_1_33 n_1_34 1k
Rh_1_34 n_1_34 n_1_35 1k
Rh_1_35 n_1_35 n_1_36 1k
Rh_1_36 n_1_36 n_1_37 1k
Rh_1_37 n_1_37 n_1_38 1k

* Row 2
Rh_2_0 n_2_0 n_2_1 1k
Rh_2_1 n_2_1 n_2_2 1k
Rh_2_2 n_2_2 n_2_3 1k
Rh_2_3 n_2_3 n_2_4 1k
Rh_2_4 n_2_4 n_2_5 1k
Rh_2_5 n_2_5 n_2_6 1k
Rh_2_6 n_2_6 n_2_7 1k
Rh_2_7 n_2_7 n_2_8 1k
Rh_2_8 n_2_8 n_2_9 1k
Rh_2_9 n_2_9 n_2_10 1k
Rh_2_10 n_2_10 n_2_11 1k
Rh_2_11 n_2_11 n_2_12 1k
Rh_2_12 n_2_12 n_2_13 1k
Rh_2_13 n_2_13 n_2_14 1k
Rh_2_14 n_2_14 n_2_15 1k
Rh_2_15 n_2_15 n_2_16 1k
Rh_2_16 n_2_16 n_2_17 1k
Rh_2_17 n_2_17 n_2_18 1k
Rh_2_18 n_2_18 n_2_19 1k
Rh_2_19 n_2_19 n_2_20 1k
Rh_2_20 n_2_20 n_2_21 1k
Rh_2_21 n_2_21 n_2_22 1k
Rh_2_22 n_2_22 n_2_23 1k
Rh_2_23 n_2_23 n_2_24 1k
Rh_2_24 n_2_24 n_2_25 1k
Rh_2_25 n_2_25 n_2_26 1k
Rh_2_26 n_2_26 n_2_27 1k
Rh_2_27 n_2_27 n_2_28 1k
Rh_2_28 n_2_28 n_2_29 1k
Rh_2_29 n_2_29 n_2_30 1k
Rh_2_30 n_2_30 n_2_31 1k
Rh_2_31 n_2_31 n_2_32 1k
Rh_2_32 n_2_32 n_2_33 1k
Rh_2_33 n_2_33 n_2_34 1k
Rh_2_34 n_2_34 n_2_35 1k
Rh_2_35 n_2_35 n_2_36 1k
Rh_2_36 n_2_36 n_2_37 1k
Rh_2_37 n_2_37 n_2_38 1k

* Row 3
Rh_3_0 n_3_0 n_3_1 1k
Rh_3_1 n_3_1 n_3_2 1k
Rh_3_2 n_3_2 n_3_3 1k
Rh_3_3 n_3_3 n_3_4 1k
Rh_3_4 n_3_4 n_3_5 1k
Rh_3_5 n_3_5 n_3_6 1k
Rh_3_6 n_3_6 n_3_7 1k
Rh_3_7 n_3_7 n_3_8 1k
Rh_3_8 n_3_8 n_3_9 1k
Rh_3_9 n_3_9 n_3_10 1k
Rh_3_10 n_3_10 n_3_11 1k
Rh_3_11 n_3_11 n_3_12 1k
Rh_3_12 n_3_12 n_3_13 1k
Rh_3_13 n_3_13 n_3_14 1k
Rh_3_14 n_3_14 n_3_15 1k
Rh_3_15 n_3_15 n_3_16 1k
Rh_3_16 n_3_16 n_3_17 1k
Rh_3_17 n_3_17 n_3_18 1k
Rh_3_18 n_3_18 n_3_19 1k
Rh_3_19 n_3_19 n_3_20 1k
Rh_3_20 n_3_20 n_3_21 1k
Rh_3_21 n_3_21 n_3_22 1k
Rh_3_22 n_3_22 n_3_23 1k
Rh_3_23 n_3_23 n_3_24 1k
Rh_3_24 n_3_24 n_3_25 1k
Rh_3_25 n_3_25 n_3_26 1k
Rh_3_26 n_3_26 n_3_27 1k
Rh_3_27 n_3_27 n_3_28 1k
Rh_3_28 n_3_28 n_3_29 1k
Rh_3_29 n_3_29 n_3_30 1k
Rh_3_30 n_3_30 n_3_31 1k
Rh_3_31 n_3_31 n_3_32 1k
Rh_3_32 n_3_32 n_3_33 1k
Rh_3_33 n_3_33 n_3_34 1k
Rh_3_34 n_3_34 n_3_35 1k
Rh_3_35 n_3_35 n_3_36 1k
Rh_3_36 n_3_36 n_3_37 1k
Rh_3_37 n_3_37 n_3_38 1k

* Row 4
Rh_4_0 n_4_0 n_4_1 1k
Rh_4_1 n_4_1 n_4_2 1k
Rh_4_2 n_4_2 n_4_3 1k
Rh_4_3 n_4_3 n_4_4 1k
Rh_4_4 n_4_4 n_4_5 1k
Rh_4_5 n_4_5 n_4_6 1k
Rh_4_6 n_4_6 n_4_7 1k
Rh_4_7 n_4_7 n_4_8 1k
Rh_4_8 n_4_8 n_4_9 1k
Rh_4_9 n_4_9 n_4_10 1k
Rh_4_10 n_4_10 n_4_11 1k
Rh_4_11 n_4_11 n_4_12 1k
Rh_4_12 n_4_12 n_4_13 1k
Rh_4_13 n_4_13 n_4_14 1k
Rh_4_14 n_4_14 n_4_15 1k
Rh_4_15 n_4_15 n_4_16 1k
Rh_4_16 n_4_16 n_4_17 1k
Rh_4_17 n_4_17 n_4_18 1k
Rh_4_18 n_4_18 n_4_19 1k
Rh_4_19 n_4_19 n_4_20 1k
Rh_4_20 n_4_20 n_4_21 1k
Rh_4_21 n_4_21 n_4_22 1k
Rh_4_22 n_4_22 n_4_23 1k
Rh_4_23 n_4_23 n_4_24 1k
Rh_4_24 n_4_24 n_4_25 1k
Rh_4_25 n_4_25 n_4_26 1k
Rh_4_26 n_4_26 n_4_27 1k
Rh_4_27 n_4_27 n_4_28 1k
Rh_4_28 n_4_28 n_4_29 1k
Rh_4_29 n_4_29 n_4_30 1k
Rh_4_30 n_4_30 n_4_31 1k
Rh_4_31 n_4_31 n_4_32 1k
Rh_4_32 n_4_32 n_4_33 1k
Rh_4_33 n_4_33 n_4_34 1k
Rh_4_34 n_4_34 n_4_35 1k
Rh_4_35 n_4_35 n_4_36 1k
Rh_4_36 n_4_36 n_4_37 1k
Rh_4_37 n_4_37 n_4_38 1k

* Row 5
Rh_5_0 n_5_0 n_5_1 1k
Rh_5_1 n_5_1 n_5_2 1k
Rh_5_2 n_5_2 n_5_3 1k
Rh_5_3 n_5_3 n_5_4 1k
Rh_5_4 n_5_4 n_5_5 1k
Rh_5_5 n_5_5 n_5_6 1k
Rh_5_6 n_5_6 n_5_7 1k
Rh_5_7 n_5_7 n_5_8 1k
Rh_5_8 n_5_8 n_5_9 1k
Rh_5_9 n_5_9 n_5_10 1k
Rh_5_10 n_5_10 n_5_11 1k
Rh_5_11 n_5_11 n_5_12 1k
Rh_5_12 n_5_12 n_5_13 1k
Rh_5_13 n_5_13 n_5_14 1k
Rh_5_14 n_5_14 n_5_15 1k
Rh_5_15 n_5_15 n_5_16 1k
Rh_5_16 n_5_16 n_5_17 1k
Rh_5_17 n_5_17 n_5_18 1k
Rh_5_18 n_5_18 n_5_19 1k
Rh_5_19 n_5_19 n_5_20 1k
Rh_5_20 n_5_20 n_5_21 1k
Rh_5_21 n_5_21 n_5_22 1k
Rh_5_22 n_5_22 n_5_23 1k
Rh_5_23 n_5_23 n_5_24 1k
Rh_5_24 n_5_24 n_5_25 1k
Rh_5_25 n_5_25 n_5_26 1k
Rh_5_26 n_5_26 n_5_27 1k
Rh_5_27 n_5_27 n_5_28 1k
Rh_5_28 n_5_28 n_5_29 1k
Rh_5_29 n_5_29 n_5_30 1k
Rh_5_30 n_5_30 n_5_31 1k
Rh_5_31 n_5_31 n_5_32 1k
Rh_5_32 n_5_32 n_5_33 1k
Rh_5_33 n_5_33 n_5_34 1k
Rh_5_34 n_5_34 n_5_35 1k
Rh_5_35 n_5_35 n_5_36 1k
Rh_5_36 n_5_36 n_5_37 1k
Rh_5_37 n_5_37 n_5_38 1k

* Row 6
Rh_6_0 n_6_0 n_6_1 1k
Rh_6_1 n_6_1 n_6_2 1k
Rh_6_2 n_6_2 n_6_3 1k
Rh_6_3 n_6_3 n_6_4 1k
Rh_6_4 n_6_4 n_6_5 1k
Rh_6_5 n_6_5 n_6_6 1k
Rh_6_6 n_6_6 n_6_7 1k
Rh_6_7 n_6_7 n_6_8 1k
Rh_6_8 n_6_8 n_6_9 1k
Rh_6_9 n_6_9 n_6_10 1k
Rh_6_10 n_6_10 n_6_11 1k
Rh_6_11 n_6_11 n_6_12 1k
Rh_6_12 n_6_12 n_6_13 1k
Rh_6_13 n_6_13 n_6_14 1k
Rh_6_14 n_6_14 n_6_15 1k
Rh_6_15 n_6_15 n_6_16 1k
Rh_6_16 n_6_16 n_6_17 1k
Rh_6_17 n_6_17 n_6_18 1k
Rh_6_18 n_6_18 n_6_19 1k
Rh_6_19 n_6_19 n_6_20 1k
Rh_6_20 n_6_20 n_6_21 1k
Rh_6_21 n_6_21 n_6_22 1k
Rh_6_22 n_6_22 n_6_23 1k
Rh_6_23 n_6_23 n_6_24 1k
Rh_6_24 n_6_24 n_6_25 1k
Rh_6_25 n_6_25 n_6_26 1k
Rh_6_26 n_6_26 n_6_27 1k
Rh_6_27 n_6_27 n_6_28 1k
Rh_6_28 n_6_28 n_6_29 1k
Rh_6_29 n_6_29 n_6_30 1k
Rh_6_30 n_6_30 n_6_31 1k
Rh_6_31 n_6_31 n_6_32 1k
Rh_6_32 n_6_32 n_6_33 1k
Rh_6_33 n_6_33 n_6_34 1k
Rh_6_34 n_6_34 n_6_35 1k
Rh_6_35 n_6_35 n_6_36 1k
Rh_6_36 n_6_36 n_6_37 1k
Rh_6_37 n_6_37 n_6_38 1k

* Row 7
Rh_7_0 n_7_0 n_7_1 1k
Rh_7_1 n_7_1 n_7_2 1k
Rh_7_2 n_7_2 n_7_3 1k
Rh_7_3 n_7_3 n_7_4 1k
Rh_7_4 n_7_4 n_7_5 1k
Rh_7_5 n_7_5 n_7_6 1k
Rh_7_6 n_7_6 n_7_7 1k
Rh_7_7 n_7_7 n_7_8 1k
Rh_7_8 n_7_8 n_7_9 1k
Rh_7_9 n_7_9 n_7_10 1k
Rh_7_10 n_7_10 n_7_11 1k
Rh_7_11 n_7_11 n_7_12 1k
Rh_7_12 n_7_12 n_7_13 1k
Rh_7_13 n_7_13 n_7_14 1k
Rh_7_14 n_7_14 n_7_15 1k
Rh_7_15 n_7_15 n_7_16 1k
Rh_7_16 n_7_16 n_7_17 1k
Rh_7_17 n_7_17 n_7_18 1k
Rh_7_18 n_7_18 n_7_19 1k
Rh_7_19 n_7_19 n_7_20 1k
Rh_7_20 n_7_20 n_7_21 1k
Rh_7_21 n_7_21 n_7_22 1k
Rh_7_22 n_7_22 n_7_23 1k
Rh_7_23 n_7_23 n_7_24 1k
Rh_7_24 n_7_24 n_7_25 1k
Rh_7_25 n_7_25 n_7_26 1k
Rh_7_26 n_7_26 n_7_27 1k
Rh_7_27 n_7_27 n_7_28 1k
Rh_7_28 n_7_28 n_7_29 1k
Rh_7_29 n_7_29 n_7_30 1k
Rh_7_30 n_7_30 n_7_31 1k
Rh_7_31 n_7_31 n_7_32 1k
Rh_7_32 n_7_32 n_7_33 1k
Rh_7_33 n_7_33 n_7_34 1k
Rh_7_34 n_7_34 n_7_35 1k
Rh_7_35 n_7_35 n_7_36 1k
Rh_7_36 n_7_36 n_7_37 1k
Rh_7_37 n_7_37 n_7_38 1k

* Row 8
Rh_8_0 n_8_0 n_8_1 1k
Rh_8_1 n_8_1 n_8_2 1k
Rh_8_2 n_8_2 n_8_3 1k
Rh_8_3 n_8_3 n_8_4 1k
Rh_8_4 n_8_4 n_8_5 1k
Rh_8_5 n_8_5 n_8_6 1k
Rh_8_6 n_8_6 n_8_7 1k
Rh_8_7 n_8_7 n_8_8 1k
Rh_8_8 n_8_8 n_8_9 1k
Rh_8_9 n_8_9 n_8_10 1k
Rh_8_10 n_8_10 n_8_11 1k
Rh_8_11 n_8_11 n_8_12 1k
Rh_8_12 n_8_12 n_8_13 1k
Rh_8_13 n_8_13 n_8_14 1k
Rh_8_14 n_8_14 n_8_15 1k
Rh_8_15 n_8_15 n_8_16 1k
Rh_8_16 n_8_16 n_8_17 1k
Rh_8_17 n_8_17 n_8_18 1k
Rh_8_18 n_8_18 n_8_19 1k
Rh_8_19 n_8_19 n_8_20 1k
Rh_8_20 n_8_20 n_8_21 1k
Rh_8_21 n_8_21 n_8_22 1k
Rh_8_22 n_8_22 n_8_23 1k
Rh_8_23 n_8_23 n_8_24 1k
Rh_8_24 n_8_24 n_8_25 1k
Rh_8_25 n_8_25 n_8_26 1k
Rh_8_26 n_8_26 n_8_27 1k
Rh_8_27 n_8_27 n_8_28 1k
Rh_8_28 n_8_28 n_8_29 1k
Rh_8_29 n_8_29 n_8_30 1k
Rh_8_30 n_8_30 n_8_31 1k
Rh_8_31 n_8_31 n_8_32 1k
Rh_8_32 n_8_32 n_8_33 1k
Rh_8_33 n_8_33 n_8_34 1k
Rh_8_34 n_8_34 n_8_35 1k
Rh_8_35 n_8_35 n_8_36 1k
Rh_8_36 n_8_36 n_8_37 1k
Rh_8_37 n_8_37 n_8_38 1k

* Row 9
Rh_9_0 n_9_0 n_9_1 1k
Rh_9_1 n_9_1 n_9_2 1k
Rh_9_2 n_9_2 n_9_3 1k
Rh_9_3 n_9_3 n_9_4 1k
Rh_9_4 n_9_4 n_9_5 1k
Rh_9_5 n_9_5 n_9_6 1k
Rh_9_6 n_9_6 n_9_7 1k
Rh_9_7 n_9_7 n_9_8 1k
Rh_9_8 n_9_8 n_9_9 1k
Rh_9_9 n_9_9 n_9_10 1k
Rh_9_10 n_9_10 n_9_11 1k
Rh_9_11 n_9_11 n_9_12 1k
Rh_9_12 n_9_12 n_9_13 1k
Rh_9_13 n_9_13 n_9_14 1k
Rh_9_14 n_9_14 n_9_15 1k
Rh_9_15 n_9_15 n_9_16 1k
Rh_9_16 n_9_16 n_9_17 1k
Rh_9_17 n_9_17 n_9_18 1k
Rh_9_18 n_9_18 n_9_19 1k
Rh_9_19 n_9_19 n_9_20 1k
Rh_9_20 n_9_20 n_9_21 1k
Rh_9_21 n_9_21 n_9_22 1k
Rh_9_22 n_9_22 n_9_23 1k
Rh_9_23 n_9_23 n_9_24 1k
Rh_9_24 n_9_24 n_9_25 1k
Rh_9_25 n_9_25 n_9_26 1k
Rh_9_26 n_9_26 n_9_27 1k
Rh_9_27 n_9_27 n_9_28 1k
Rh_9_28 n_9_28 n_9_29 1k
Rh_9_29 n_9_29 n_9_30 1k
Rh_9_30 n_9_30 n_9_31 1k
Rh_9_31 n_9_31 n_9_32 1k
Rh_9_32 n_9_32 n_9_33 1k
Rh_9_33 n_9_33 n_9_34 1k
Rh_9_34 n_9_34 n_9_35 1k
Rh_9_35 n_9_35 n_9_36 1k
Rh_9_36 n_9_36 n_9_37 1k
Rh_9_37 n_9_37 n_9_38 1k

* Row 10
Rh_10_0 n_10_0 n_10_1 1k
Rh_10_1 n_10_1 n_10_2 1k
Rh_10_2 n_10_2 n_10_3 1k
Rh_10_3 n_10_3 n_10_4 1k
Rh_10_4 n_10_4 n_10_5 1k
Rh_10_5 n_10_5 n_10_6 1k
Rh_10_6 n_10_6 n_10_7 1k
Rh_10_7 n_10_7 n_10_8 1k
Rh_10_8 n_10_8 n_10_9 1k
Rh_10_9 n_10_9 n_10_10 1k
Rh_10_10 n_10_10 n_10_11 1k
Rh_10_11 n_10_11 n_10_12 1k
Rh_10_12 n_10_12 n_10_13 1k
Rh_10_13 n_10_13 n_10_14 1k
Rh_10_14 n_10_14 n_10_15 1k
Rh_10_15 n_10_15 n_10_16 1k
Rh_10_16 n_10_16 n_10_17 1k
Rh_10_17 n_10_17 n_10_18 1k
Rh_10_18 n_10_18 n_10_19 1k
Rh_10_19 n_10_19 n_10_20 1k
Rh_10_20 n_10_20 n_10_21 1k
Rh_10_21 n_10_21 n_10_22 1k
Rh_10_22 n_10_22 n_10_23 1k
Rh_10_23 n_10_23 n_10_24 1k
Rh_10_24 n_10_24 n_10_25 1k
Rh_10_25 n_10_25 n_10_26 1k
Rh_10_26 n_10_26 n_10_27 1k
Rh_10_27 n_10_27 n_10_28 1k
Rh_10_28 n_10_28 n_10_29 1k
Rh_10_29 n_10_29 n_10_30 1k
Rh_10_30 n_10_30 n_10_31 1k
Rh_10_31 n_10_31 n_10_32 1k
Rh_10_32 n_10_32 n_10_33 1k
Rh_10_33 n_10_33 n_10_34 1k
Rh_10_34 n_10_34 n_10_35 1k
Rh_10_35 n_10_35 n_10_36 1k
Rh_10_36 n_10_36 n_10_37 1k
Rh_10_37 n_10_37 n_10_38 1k

* Row 11
Rh_11_0 n_11_0 n_11_1 1k
Rh_11_1 n_11_1 n_11_2 1k
Rh_11_2 n_11_2 n_11_3 1k
Rh_11_3 n_11_3 n_11_4 1k
Rh_11_4 n_11_4 n_11_5 1k
Rh_11_5 n_11_5 n_11_6 1k
Rh_11_6 n_11_6 n_11_7 1k
Rh_11_7 n_11_7 n_11_8 1k
Rh_11_8 n_11_8 n_11_9 1k
Rh_11_9 n_11_9 n_11_10 1k
Rh_11_10 n_11_10 n_11_11 1k
Rh_11_11 n_11_11 n_11_12 1k
Rh_11_12 n_11_12 n_11_13 1k
Rh_11_13 n_11_13 n_11_14 1k
Rh_11_14 n_11_14 n_11_15 1k
Rh_11_15 n_11_15 n_11_16 1k
Rh_11_16 n_11_16 n_11_17 1k
Rh_11_17 n_11_17 n_11_18 1k
Rh_11_18 n_11_18 n_11_19 1k
Rh_11_19 n_11_19 n_11_20 1k
Rh_11_20 n_11_20 n_11_21 1k
Rh_11_21 n_11_21 n_11_22 1k
Rh_11_22 n_11_22 n_11_23 1k
Rh_11_23 n_11_23 n_11_24 1k
Rh_11_24 n_11_24 n_11_25 1k
Rh_11_25 n_11_25 n_11_26 1k
Rh_11_26 n_11_26 n_11_27 1k
Rh_11_27 n_11_27 n_11_28 1k
Rh_11_28 n_11_28 n_11_29 1k
Rh_11_29 n_11_29 n_11_30 1k
Rh_11_30 n_11_30 n_11_31 1k
Rh_11_31 n_11_31 n_11_32 1k
Rh_11_32 n_11_32 n_11_33 1k
Rh_11_33 n_11_33 n_11_34 1k
Rh_11_34 n_11_34 n_11_35 1k
Rh_11_35 n_11_35 n_11_36 1k
Rh_11_36 n_11_36 n_11_37 1k
Rh_11_37 n_11_37 n_11_38 1k

* Row 12
Rh_12_0 n_12_0 n_12_1 1k
Rh_12_1 n_12_1 n_12_2 1k
Rh_12_2 n_12_2 n_12_3 1k
Rh_12_3 n_12_3 n_12_4 1k
Rh_12_4 n_12_4 n_12_5 1k
Rh_12_5 n_12_5 n_12_6 1k
Rh_12_6 n_12_6 n_12_7 1k
Rh_12_7 n_12_7 n_12_8 1k
Rh_12_8 n_12_8 n_12_9 1k
Rh_12_9 n_12_9 n_12_10 1k
Rh_12_10 n_12_10 n_12_11 1k
Rh_12_11 n_12_11 n_12_12 1k
Rh_12_12 n_12_12 n_12_13 1k
Rh_12_13 n_12_13 n_12_14 1k
Rh_12_14 n_12_14 n_12_15 1k
Rh_12_15 n_12_15 n_12_16 1k
Rh_12_16 n_12_16 n_12_17 1k
Rh_12_17 n_12_17 n_12_18 1k
Rh_12_18 n_12_18 n_12_19 1k
Rh_12_19 n_12_19 n_12_20 1k
Rh_12_20 n_12_20 n_12_21 1k
Rh_12_21 n_12_21 n_12_22 1k
Rh_12_22 n_12_22 n_12_23 1k
Rh_12_23 n_12_23 n_12_24 1k
Rh_12_24 n_12_24 n_12_25 1k
Rh_12_25 n_12_25 n_12_26 1k
Rh_12_26 n_12_26 n_12_27 1k
Rh_12_27 n_12_27 n_12_28 1k
Rh_12_28 n_12_28 n_12_29 1k
Rh_12_29 n_12_29 n_12_30 1k
Rh_12_30 n_12_30 n_12_31 1k
Rh_12_31 n_12_31 n_12_32 1k
Rh_12_32 n_12_32 n_12_33 1k
Rh_12_33 n_12_33 n_12_34 1k
Rh_12_34 n_12_34 n_12_35 1k
Rh_12_35 n_12_35 n_12_36 1k
Rh_12_36 n_12_36 n_12_37 1k
Rh_12_37 n_12_37 n_12_38 1k

* Row 13
Rh_13_0 n_13_0 n_13_1 1k
Rh_13_1 n_13_1 n_13_2 1k
Rh_13_2 n_13_2 n_13_3 1k
Rh_13_3 n_13_3 n_13_4 1k
Rh_13_4 n_13_4 n_13_5 1k
Rh_13_5 n_13_5 n_13_6 1k
Rh_13_6 n_13_6 n_13_7 1k
Rh_13_7 n_13_7 n_13_8 1k
Rh_13_8 n_13_8 n_13_9 1k
Rh_13_9 n_13_9 n_13_10 1k
Rh_13_10 n_13_10 n_13_11 1k
Rh_13_11 n_13_11 n_13_12 1k
Rh_13_12 n_13_12 n_13_13 1k
Rh_13_13 n_13_13 n_13_14 1k
Rh_13_14 n_13_14 n_13_15 1k
Rh_13_15 n_13_15 n_13_16 1k
Rh_13_16 n_13_16 n_13_17 1k
Rh_13_17 n_13_17 n_13_18 1k
Rh_13_18 n_13_18 n_13_19 1k
Rh_13_19 n_13_19 n_13_20 1k
Rh_13_20 n_13_20 n_13_21 1k
Rh_13_21 n_13_21 n_13_22 1k
Rh_13_22 n_13_22 n_13_23 1k
Rh_13_23 n_13_23 n_13_24 1k
Rh_13_24 n_13_24 n_13_25 1k
Rh_13_25 n_13_25 n_13_26 1k
Rh_13_26 n_13_26 n_13_27 1k
Rh_13_27 n_13_27 n_13_28 1k
Rh_13_28 n_13_28 n_13_29 1k
Rh_13_29 n_13_29 n_13_30 1k
Rh_13_30 n_13_30 n_13_31 1k
Rh_13_31 n_13_31 n_13_32 1k
Rh_13_32 n_13_32 n_13_33 1k
Rh_13_33 n_13_33 n_13_34 1k
Rh_13_34 n_13_34 n_13_35 1k
Rh_13_35 n_13_35 n_13_36 1k
Rh_13_36 n_13_36 n_13_37 1k
Rh_13_37 n_13_37 n_13_38 1k

* Row 14
Rh_14_0 n_14_0 n_14_1 1k
Rh_14_1 n_14_1 n_14_2 1k
Rh_14_2 n_14_2 n_14_3 1k
Rh_14_3 n_14_3 n_14_4 1k
Rh_14_4 n_14_4 n_14_5 1k
Rh_14_5 n_14_5 n_14_6 1k
Rh_14_6 n_14_6 n_14_7 1k
Rh_14_7 n_14_7 n_14_8 1k
Rh_14_8 n_14_8 n_14_9 1k
Rh_14_9 n_14_9 n_14_10 1k
Rh_14_10 n_14_10 n_14_11 1k
Rh_14_11 n_14_11 n_14_12 1k
Rh_14_12 n_14_12 n_14_13 1k
Rh_14_13 n_14_13 n_14_14 1k
Rh_14_14 n_14_14 n_14_15 1k
Rh_14_15 n_14_15 n_14_16 1k
Rh_14_16 n_14_16 n_14_17 1k
Rh_14_17 n_14_17 n_14_18 1k
Rh_14_18 n_14_18 n_14_19 1k
Rh_14_19 n_14_19 n_14_20 1k
Rh_14_20 n_14_20 n_14_21 1k
Rh_14_21 n_14_21 n_14_22 1k
Rh_14_22 n_14_22 n_14_23 1k
Rh_14_23 n_14_23 n_14_24 1k
Rh_14_24 n_14_24 n_14_25 1k
Rh_14_25 n_14_25 n_14_26 1k
Rh_14_26 n_14_26 n_14_27 1k
Rh_14_27 n_14_27 n_14_28 1k
Rh_14_28 n_14_28 n_14_29 1k
Rh_14_29 n_14_29 n_14_30 1k
Rh_14_30 n_14_30 n_14_31 1k
Rh_14_31 n_14_31 n_14_32 1k
Rh_14_32 n_14_32 n_14_33 1k
Rh_14_33 n_14_33 n_14_34 1k
Rh_14_34 n_14_34 n_14_35 1k
Rh_14_35 n_14_35 n_14_36 1k
Rh_14_36 n_14_36 n_14_37 1k
Rh_14_37 n_14_37 n_14_38 1k

* Row 15
Rh_15_0 n_15_0 n_15_1 1k
Rh_15_1 n_15_1 n_15_2 1k
Rh_15_2 n_15_2 n_15_3 1k
Rh_15_3 n_15_3 n_15_4 1k
Rh_15_4 n_15_4 n_15_5 1k
Rh_15_5 n_15_5 n_15_6 1k
Rh_15_6 n_15_6 n_15_7 1k
Rh_15_7 n_15_7 n_15_8 1k
Rh_15_8 n_15_8 n_15_9 1k
Rh_15_9 n_15_9 n_15_10 1k
Rh_15_10 n_15_10 n_15_11 1k
Rh_15_11 n_15_11 n_15_12 1k
Rh_15_12 n_15_12 n_15_13 1k
Rh_15_13 n_15_13 n_15_14 1k
Rh_15_14 n_15_14 n_15_15 1k
Rh_15_15 n_15_15 n_15_16 1k
Rh_15_16 n_15_16 n_15_17 1k
Rh_15_17 n_15_17 n_15_18 1k
Rh_15_18 n_15_18 n_15_19 1k
Rh_15_19 n_15_19 n_15_20 1k
Rh_15_20 n_15_20 n_15_21 1k
Rh_15_21 n_15_21 n_15_22 1k
Rh_15_22 n_15_22 n_15_23 1k
Rh_15_23 n_15_23 n_15_24 1k
Rh_15_24 n_15_24 n_15_25 1k
Rh_15_25 n_15_25 n_15_26 1k
Rh_15_26 n_15_26 n_15_27 1k
Rh_15_27 n_15_27 n_15_28 1k
Rh_15_28 n_15_28 n_15_29 1k
Rh_15_29 n_15_29 n_15_30 1k
Rh_15_30 n_15_30 n_15_31 1k
Rh_15_31 n_15_31 n_15_32 1k
Rh_15_32 n_15_32 n_15_33 1k
Rh_15_33 n_15_33 n_15_34 1k
Rh_15_34 n_15_34 n_15_35 1k
Rh_15_35 n_15_35 n_15_36 1k
Rh_15_36 n_15_36 n_15_37 1k
Rh_15_37 n_15_37 n_15_38 1k

* Row 16
Rh_16_0 n_16_0 n_16_1 1k
Rh_16_1 n_16_1 n_16_2 1k
Rh_16_2 n_16_2 n_16_3 1k
Rh_16_3 n_16_3 n_16_4 1k
Rh_16_4 n_16_4 n_16_5 1k
Rh_16_5 n_16_5 n_16_6 1k
Rh_16_6 n_16_6 n_16_7 1k
Rh_16_7 n_16_7 n_16_8 1k
Rh_16_8 n_16_8 n_16_9 1k
Rh_16_9 n_16_9 n_16_10 1k
Rh_16_10 n_16_10 n_16_11 1k
Rh_16_11 n_16_11 n_16_12 1k
Rh_16_12 n_16_12 n_16_13 1k
Rh_16_13 n_16_13 n_16_14 1k
Rh_16_14 n_16_14 n_16_15 1k
Rh_16_15 n_16_15 n_16_16 1k
Rh_16_16 n_16_16 n_16_17 1k
Rh_16_17 n_16_17 n_16_18 1k
Rh_16_18 n_16_18 n_16_19 1k
Rh_16_19 n_16_19 n_16_20 1k
Rh_16_20 n_16_20 n_16_21 1k
Rh_16_21 n_16_21 n_16_22 1k
Rh_16_22 n_16_22 n_16_23 1k
Rh_16_23 n_16_23 n_16_24 1k
Rh_16_24 n_16_24 n_16_25 1k
Rh_16_25 n_16_25 n_16_26 1k
Rh_16_26 n_16_26 n_16_27 1k
Rh_16_27 n_16_27 n_16_28 1k
Rh_16_28 n_16_28 n_16_29 1k
Rh_16_29 n_16_29 n_16_30 1k
Rh_16_30 n_16_30 n_16_31 1k
Rh_16_31 n_16_31 n_16_32 1k
Rh_16_32 n_16_32 n_16_33 1k
Rh_16_33 n_16_33 n_16_34 1k
Rh_16_34 n_16_34 n_16_35 1k
Rh_16_35 n_16_35 n_16_36 1k
Rh_16_36 n_16_36 n_16_37 1k
Rh_16_37 n_16_37 n_16_38 1k

* Row 17
Rh_17_0 n_17_0 n_17_1 1k
Rh_17_1 n_17_1 n_17_2 1k
Rh_17_2 n_17_2 n_17_3 1k
Rh_17_3 n_17_3 n_17_4 1k
Rh_17_4 n_17_4 n_17_5 1k
Rh_17_5 n_17_5 n_17_6 1k
Rh_17_6 n_17_6 n_17_7 1k
Rh_17_7 n_17_7 n_17_8 1k
Rh_17_8 n_17_8 n_17_9 1k
Rh_17_9 n_17_9 n_17_10 1k
Rh_17_10 n_17_10 n_17_11 1k
Rh_17_11 n_17_11 n_17_12 1k
Rh_17_12 n_17_12 n_17_13 1k
Rh_17_13 n_17_13 n_17_14 1k
Rh_17_14 n_17_14 n_17_15 1k
Rh_17_15 n_17_15 n_17_16 1k
Rh_17_16 n_17_16 n_17_17 1k
Rh_17_17 n_17_17 n_17_18 1k
Rh_17_18 n_17_18 n_17_19 1k
Rh_17_19 n_17_19 n_17_20 1k
Rh_17_20 n_17_20 n_17_21 1k
Rh_17_21 n_17_21 n_17_22 1k
Rh_17_22 n_17_22 n_17_23 1k
Rh_17_23 n_17_23 n_17_24 1k
Rh_17_24 n_17_24 n_17_25 1k
Rh_17_25 n_17_25 n_17_26 1k
Rh_17_26 n_17_26 n_17_27 1k
Rh_17_27 n_17_27 n_17_28 1k
Rh_17_28 n_17_28 n_17_29 1k
Rh_17_29 n_17_29 n_17_30 1k
Rh_17_30 n_17_30 n_17_31 1k
Rh_17_31 n_17_31 n_17_32 1k
Rh_17_32 n_17_32 n_17_33 1k
Rh_17_33 n_17_33 n_17_34 1k
Rh_17_34 n_17_34 n_17_35 1k
Rh_17_35 n_17_35 n_17_36 1k
Rh_17_36 n_17_36 n_17_37 1k
Rh_17_37 n_17_37 n_17_38 1k

* Row 18
Rh_18_0 n_18_0 n_18_1 1k
Rh_18_1 n_18_1 n_18_2 1k
Rh_18_2 n_18_2 n_18_3 1k
Rh_18_3 n_18_3 n_18_4 1k
Rh_18_4 n_18_4 n_18_5 1k
Rh_18_5 n_18_5 n_18_6 1k
Rh_18_6 n_18_6 n_18_7 1k
Rh_18_7 n_18_7 n_18_8 1k
Rh_18_8 n_18_8 n_18_9 1k
Rh_18_9 n_18_9 n_18_10 1k
Rh_18_10 n_18_10 n_18_11 1k
Rh_18_11 n_18_11 n_18_12 1k
Rh_18_12 n_18_12 n_18_13 1k
Rh_18_13 n_18_13 n_18_14 1k
Rh_18_14 n_18_14 n_18_15 1k
Rh_18_15 n_18_15 n_18_16 1k
Rh_18_16 n_18_16 n_18_17 1k
Rh_18_17 n_18_17 n_18_18 1k
Rh_18_18 n_18_18 n_18_19 1k
Rh_18_19 n_18_19 n_18_20 1k
Rh_18_20 n_18_20 n_18_21 1k
Rh_18_21 n_18_21 n_18_22 1k
Rh_18_22 n_18_22 n_18_23 1k
Rh_18_23 n_18_23 n_18_24 1k
Rh_18_24 n_18_24 n_18_25 1k
Rh_18_25 n_18_25 n_18_26 1k
Rh_18_26 n_18_26 n_18_27 1k
Rh_18_27 n_18_27 n_18_28 1k
Rh_18_28 n_18_28 n_18_29 1k
Rh_18_29 n_18_29 n_18_30 1k
Rh_18_30 n_18_30 n_18_31 1k
Rh_18_31 n_18_31 n_18_32 1k
Rh_18_32 n_18_32 n_18_33 1k
Rh_18_33 n_18_33 n_18_34 1k
Rh_18_34 n_18_34 n_18_35 1k
Rh_18_35 n_18_35 n_18_36 1k
Rh_18_36 n_18_36 n_18_37 1k
Rh_18_37 n_18_37 n_18_38 1k

* Row 19
Rh_19_0 n_19_0 n_19_1 1k
Rh_19_1 n_19_1 n_19_2 1k
Rh_19_2 n_19_2 n_19_3 1k
Rh_19_3 n_19_3 n_19_4 1k
Rh_19_4 n_19_4 n_19_5 1k
Rh_19_5 n_19_5 n_19_6 1k
Rh_19_6 n_19_6 n_19_7 1k
Rh_19_7 n_19_7 n_19_8 1k
Rh_19_8 n_19_8 n_19_9 1k
Rh_19_9 n_19_9 n_19_10 1k
Rh_19_10 n_19_10 n_19_11 1k
Rh_19_11 n_19_11 n_19_12 1k
Rh_19_12 n_19_12 n_19_13 1k
Rh_19_13 n_19_13 n_19_14 1k
Rh_19_14 n_19_14 n_19_15 1k
Rh_19_15 n_19_15 n_19_16 1k
Rh_19_16 n_19_16 n_19_17 1k
Rh_19_17 n_19_17 n_19_18 1k
Rh_19_18 n_19_18 n_19_19 1k
Rh_19_19 n_19_19 n_19_20 1k
Rh_19_20 n_19_20 n_19_21 1k
Rh_19_21 n_19_21 n_19_22 1k
Rh_19_22 n_19_22 n_19_23 1k
Rh_19_23 n_19_23 n_19_24 1k
Rh_19_24 n_19_24 n_19_25 1k
Rh_19_25 n_19_25 n_19_26 1k
Rh_19_26 n_19_26 n_19_27 1k
Rh_19_27 n_19_27 n_19_28 1k
Rh_19_28 n_19_28 n_19_29 1k
Rh_19_29 n_19_29 n_19_30 1k
Rh_19_30 n_19_30 n_19_31 1k
Rh_19_31 n_19_31 n_19_32 1k
Rh_19_32 n_19_32 n_19_33 1k
Rh_19_33 n_19_33 n_19_34 1k
Rh_19_34 n_19_34 n_19_35 1k
Rh_19_35 n_19_35 n_19_36 1k
Rh_19_36 n_19_36 n_19_37 1k
Rh_19_37 n_19_37 n_19_38 1k

* Row 20
Rh_20_0 n_20_0 n_20_1 1k
Rh_20_1 n_20_1 n_20_2 1k
Rh_20_2 n_20_2 n_20_3 1k
Rh_20_3 n_20_3 n_20_4 1k
Rh_20_4 n_20_4 n_20_5 1k
Rh_20_5 n_20_5 n_20_6 1k
Rh_20_6 n_20_6 n_20_7 1k
Rh_20_7 n_20_7 n_20_8 1k
Rh_20_8 n_20_8 n_20_9 1k
Rh_20_9 n_20_9 n_20_10 1k
Rh_20_10 n_20_10 n_20_11 1k
Rh_20_11 n_20_11 n_20_12 1k
Rh_20_12 n_20_12 n_20_13 1k
Rh_20_13 n_20_13 n_20_14 1k
Rh_20_14 n_20_14 n_20_15 1k
Rh_20_15 n_20_15 n_20_16 1k
Rh_20_16 n_20_16 n_20_17 1k
Rh_20_17 n_20_17 n_20_18 1k
Rh_20_18 n_20_18 n_20_19 1k
Rh_20_19 n_20_19 n_20_20 1k
Rh_20_20 n_20_20 n_20_21 1k
Rh_20_21 n_20_21 n_20_22 1k
Rh_20_22 n_20_22 n_20_23 1k
Rh_20_23 n_20_23 n_20_24 1k
Rh_20_24 n_20_24 n_20_25 1k
Rh_20_25 n_20_25 n_20_26 1k
Rh_20_26 n_20_26 n_20_27 1k
Rh_20_27 n_20_27 n_20_28 1k
Rh_20_28 n_20_28 n_20_29 1k
Rh_20_29 n_20_29 n_20_30 1k
Rh_20_30 n_20_30 n_20_31 1k
Rh_20_31 n_20_31 n_20_32 1k
Rh_20_32 n_20_32 n_20_33 1k
Rh_20_33 n_20_33 n_20_34 1k
Rh_20_34 n_20_34 n_20_35 1k
Rh_20_35 n_20_35 n_20_36 1k
Rh_20_36 n_20_36 n_20_37 1k
Rh_20_37 n_20_37 n_20_38 1k

* Row 21
Rh_21_0 n_21_0 n_21_1 1k
Rh_21_1 n_21_1 n_21_2 1k
Rh_21_2 n_21_2 n_21_3 1k
Rh_21_3 n_21_3 n_21_4 1k
Rh_21_4 n_21_4 n_21_5 1k
Rh_21_5 n_21_5 n_21_6 1k
Rh_21_6 n_21_6 n_21_7 1k
Rh_21_7 n_21_7 n_21_8 1k
Rh_21_8 n_21_8 n_21_9 1k
Rh_21_9 n_21_9 n_21_10 1k
Rh_21_10 n_21_10 n_21_11 1k
Rh_21_11 n_21_11 n_21_12 1k
Rh_21_12 n_21_12 n_21_13 1k
Rh_21_13 n_21_13 n_21_14 1k
Rh_21_14 n_21_14 n_21_15 1k
Rh_21_15 n_21_15 n_21_16 1k
Rh_21_16 n_21_16 n_21_17 1k
Rh_21_17 n_21_17 n_21_18 1k
Rh_21_18 n_21_18 n_21_19 1k
Rh_21_19 n_21_19 n_21_20 1k
Rh_21_20 n_21_20 n_21_21 1k
Rh_21_21 n_21_21 n_21_22 1k
Rh_21_22 n_21_22 n_21_23 1k
Rh_21_23 n_21_23 n_21_24 1k
Rh_21_24 n_21_24 n_21_25 1k
Rh_21_25 n_21_25 n_21_26 1k
Rh_21_26 n_21_26 n_21_27 1k
Rh_21_27 n_21_27 n_21_28 1k
Rh_21_28 n_21_28 n_21_29 1k
Rh_21_29 n_21_29 n_21_30 1k
Rh_21_30 n_21_30 n_21_31 1k
Rh_21_31 n_21_31 n_21_32 1k
Rh_21_32 n_21_32 n_21_33 1k
Rh_21_33 n_21_33 n_21_34 1k
Rh_21_34 n_21_34 n_21_35 1k
Rh_21_35 n_21_35 n_21_36 1k
Rh_21_36 n_21_36 n_21_37 1k
Rh_21_37 n_21_37 n_21_38 1k

* Row 22
Rh_22_0 n_22_0 n_22_1 1k
Rh_22_1 n_22_1 n_22_2 1k
Rh_22_2 n_22_2 n_22_3 1k
Rh_22_3 n_22_3 n_22_4 1k
Rh_22_4 n_22_4 n_22_5 1k
Rh_22_5 n_22_5 n_22_6 1k
Rh_22_6 n_22_6 n_22_7 1k
Rh_22_7 n_22_7 n_22_8 1k
Rh_22_8 n_22_8 n_22_9 1k
Rh_22_9 n_22_9 n_22_10 1k
Rh_22_10 n_22_10 n_22_11 1k
Rh_22_11 n_22_11 n_22_12 1k
Rh_22_12 n_22_12 n_22_13 1k
Rh_22_13 n_22_13 n_22_14 1k
Rh_22_14 n_22_14 n_22_15 1k
Rh_22_15 n_22_15 n_22_16 1k
Rh_22_16 n_22_16 n_22_17 1k
Rh_22_17 n_22_17 n_22_18 1k
Rh_22_18 n_22_18 n_22_19 1k
Rh_22_19 n_22_19 n_22_20 1k
Rh_22_20 n_22_20 n_22_21 1k
Rh_22_21 n_22_21 n_22_22 1k
Rh_22_22 n_22_22 n_22_23 1k
Rh_22_23 n_22_23 n_22_24 1k
Rh_22_24 n_22_24 n_22_25 1k
Rh_22_25 n_22_25 n_22_26 1k
Rh_22_26 n_22_26 n_22_27 1k
Rh_22_27 n_22_27 n_22_28 1k
Rh_22_28 n_22_28 n_22_29 1k
Rh_22_29 n_22_29 n_22_30 1k
Rh_22_30 n_22_30 n_22_31 1k
Rh_22_31 n_22_31 n_22_32 1k
Rh_22_32 n_22_32 n_22_33 1k
Rh_22_33 n_22_33 n_22_34 1k
Rh_22_34 n_22_34 n_22_35 1k
Rh_22_35 n_22_35 n_22_36 1k
Rh_22_36 n_22_36 n_22_37 1k
Rh_22_37 n_22_37 n_22_38 1k

* Row 23
Rh_23_0 n_23_0 n_23_1 1k
Rh_23_1 n_23_1 n_23_2 1k
Rh_23_2 n_23_2 n_23_3 1k
Rh_23_3 n_23_3 n_23_4 1k
Rh_23_4 n_23_4 n_23_5 1k
Rh_23_5 n_23_5 n_23_6 1k
Rh_23_6 n_23_6 n_23_7 1k
Rh_23_7 n_23_7 n_23_8 1k
Rh_23_8 n_23_8 n_23_9 1k
Rh_23_9 n_23_9 n_23_10 1k
Rh_23_10 n_23_10 n_23_11 1k
Rh_23_11 n_23_11 n_23_12 1k
Rh_23_12 n_23_12 n_23_13 1k
Rh_23_13 n_23_13 n_23_14 1k
Rh_23_14 n_23_14 n_23_15 1k
Rh_23_15 n_23_15 n_23_16 1k
Rh_23_16 n_23_16 n_23_17 1k
Rh_23_17 n_23_17 n_23_18 1k
Rh_23_18 n_23_18 n_23_19 1k
Rh_23_19 n_23_19 n_23_20 1k
Rh_23_20 n_23_20 n_23_21 1k
Rh_23_21 n_23_21 n_23_22 1k
Rh_23_22 n_23_22 n_23_23 1k
Rh_23_23 n_23_23 n_23_24 1k
Rh_23_24 n_23_24 n_23_25 1k
Rh_23_25 n_23_25 n_23_26 1k
Rh_23_26 n_23_26 n_23_27 1k
Rh_23_27 n_23_27 n_23_28 1k
Rh_23_28 n_23_28 n_23_29 1k
Rh_23_29 n_23_29 n_23_30 1k
Rh_23_30 n_23_30 n_23_31 1k
Rh_23_31 n_23_31 n_23_32 1k
Rh_23_32 n_23_32 n_23_33 1k
Rh_23_33 n_23_33 n_23_34 1k
Rh_23_34 n_23_34 n_23_35 1k
Rh_23_35 n_23_35 n_23_36 1k
Rh_23_36 n_23_36 n_23_37 1k
Rh_23_37 n_23_37 n_23_38 1k

* Row 24
Rh_24_0 n_24_0 n_24_1 1k
Rh_24_1 n_24_1 n_24_2 1k
Rh_24_2 n_24_2 n_24_3 1k
Rh_24_3 n_24_3 n_24_4 1k
Rh_24_4 n_24_4 n_24_5 1k
Rh_24_5 n_24_5 n_24_6 1k
Rh_24_6 n_24_6 n_24_7 1k
Rh_24_7 n_24_7 n_24_8 1k
Rh_24_8 n_24_8 n_24_9 1k
Rh_24_9 n_24_9 n_24_10 1k
Rh_24_10 n_24_10 n_24_11 1k
Rh_24_11 n_24_11 n_24_12 1k
Rh_24_12 n_24_12 n_24_13 1k
Rh_24_13 n_24_13 n_24_14 1k
Rh_24_14 n_24_14 n_24_15 1k
Rh_24_15 n_24_15 n_24_16 1k
Rh_24_16 n_24_16 n_24_17 1k
Rh_24_17 n_24_17 n_24_18 1k
Rh_24_18 n_24_18 n_24_19 1k
Rh_24_19 n_24_19 n_24_20 1k
Rh_24_20 n_24_20 n_24_21 1k
Rh_24_21 n_24_21 n_24_22 1k
Rh_24_22 n_24_22 n_24_23 1k
Rh_24_23 n_24_23 n_24_24 1k
Rh_24_24 n_24_24 n_24_25 1k
Rh_24_25 n_24_25 n_24_26 1k
Rh_24_26 n_24_26 n_24_27 1k
Rh_24_27 n_24_27 n_24_28 1k
Rh_24_28 n_24_28 n_24_29 1k
Rh_24_29 n_24_29 n_24_30 1k
Rh_24_30 n_24_30 n_24_31 1k
Rh_24_31 n_24_31 n_24_32 1k
Rh_24_32 n_24_32 n_24_33 1k
Rh_24_33 n_24_33 n_24_34 1k
Rh_24_34 n_24_34 n_24_35 1k
Rh_24_35 n_24_35 n_24_36 1k
Rh_24_36 n_24_36 n_24_37 1k
Rh_24_37 n_24_37 n_24_38 1k

* Row 25
Rh_25_0 n_25_0 n_25_1 1k
Rh_25_1 n_25_1 n_25_2 1k
Rh_25_2 n_25_2 n_25_3 1k
Rh_25_3 n_25_3 n_25_4 1k
Rh_25_4 n_25_4 n_25_5 1k
Rh_25_5 n_25_5 n_25_6 1k
Rh_25_6 n_25_6 n_25_7 1k
Rh_25_7 n_25_7 n_25_8 1k
Rh_25_8 n_25_8 n_25_9 1k
Rh_25_9 n_25_9 n_25_10 1k
Rh_25_10 n_25_10 n_25_11 1k
Rh_25_11 n_25_11 n_25_12 1k
Rh_25_12 n_25_12 n_25_13 1k
Rh_25_13 n_25_13 n_25_14 1k
Rh_25_14 n_25_14 n_25_15 1k
Rh_25_15 n_25_15 n_25_16 1k
Rh_25_16 n_25_16 n_25_17 1k
Rh_25_17 n_25_17 n_25_18 1k
Rh_25_18 n_25_18 n_25_19 1k
Rh_25_19 n_25_19 n_25_20 1k
Rh_25_20 n_25_20 n_25_21 1k
Rh_25_21 n_25_21 n_25_22 1k
Rh_25_22 n_25_22 n_25_23 1k
Rh_25_23 n_25_23 n_25_24 1k
Rh_25_24 n_25_24 n_25_25 1k
Rh_25_25 n_25_25 n_25_26 1k
Rh_25_26 n_25_26 n_25_27 1k
Rh_25_27 n_25_27 n_25_28 1k
Rh_25_28 n_25_28 n_25_29 1k
Rh_25_29 n_25_29 n_25_30 1k
Rh_25_30 n_25_30 n_25_31 1k
Rh_25_31 n_25_31 n_25_32 1k
Rh_25_32 n_25_32 n_25_33 1k
Rh_25_33 n_25_33 n_25_34 1k
Rh_25_34 n_25_34 n_25_35 1k
Rh_25_35 n_25_35 n_25_36 1k
Rh_25_36 n_25_36 n_25_37 1k
Rh_25_37 n_25_37 n_25_38 1k

* Row 26
Rh_26_0 n_26_0 n_26_1 1k
Rh_26_1 n_26_1 n_26_2 1k
Rh_26_2 n_26_2 n_26_3 1k
Rh_26_3 n_26_3 n_26_4 1k
Rh_26_4 n_26_4 n_26_5 1k
Rh_26_5 n_26_5 n_26_6 1k
Rh_26_6 n_26_6 n_26_7 1k
Rh_26_7 n_26_7 n_26_8 1k
Rh_26_8 n_26_8 n_26_9 1k
Rh_26_9 n_26_9 n_26_10 1k
Rh_26_10 n_26_10 n_26_11 1k
Rh_26_11 n_26_11 n_26_12 1k
Rh_26_12 n_26_12 n_26_13 1k
Rh_26_13 n_26_13 n_26_14 1k
Rh_26_14 n_26_14 n_26_15 1k
Rh_26_15 n_26_15 n_26_16 1k
Rh_26_16 n_26_16 n_26_17 1k
Rh_26_17 n_26_17 n_26_18 1k
Rh_26_18 n_26_18 n_26_19 1k
Rh_26_19 n_26_19 n_26_20 1k
Rh_26_20 n_26_20 n_26_21 1k
Rh_26_21 n_26_21 n_26_22 1k
Rh_26_22 n_26_22 n_26_23 1k
Rh_26_23 n_26_23 n_26_24 1k
Rh_26_24 n_26_24 n_26_25 1k
Rh_26_25 n_26_25 n_26_26 1k
Rh_26_26 n_26_26 n_26_27 1k
Rh_26_27 n_26_27 n_26_28 1k
Rh_26_28 n_26_28 n_26_29 1k
Rh_26_29 n_26_29 n_26_30 1k
Rh_26_30 n_26_30 n_26_31 1k
Rh_26_31 n_26_31 n_26_32 1k
Rh_26_32 n_26_32 n_26_33 1k
Rh_26_33 n_26_33 n_26_34 1k
Rh_26_34 n_26_34 n_26_35 1k
Rh_26_35 n_26_35 n_26_36 1k
Rh_26_36 n_26_36 n_26_37 1k
Rh_26_37 n_26_37 n_26_38 1k

* Row 27
Rh_27_0 n_27_0 n_27_1 1k
Rh_27_1 n_27_1 n_27_2 1k
Rh_27_2 n_27_2 n_27_3 1k
Rh_27_3 n_27_3 n_27_4 1k
Rh_27_4 n_27_4 n_27_5 1k
Rh_27_5 n_27_5 n_27_6 1k
Rh_27_6 n_27_6 n_27_7 1k
Rh_27_7 n_27_7 n_27_8 1k
Rh_27_8 n_27_8 n_27_9 1k
Rh_27_9 n_27_9 n_27_10 1k
Rh_27_10 n_27_10 n_27_11 1k
Rh_27_11 n_27_11 n_27_12 1k
Rh_27_12 n_27_12 n_27_13 1k
Rh_27_13 n_27_13 n_27_14 1k
Rh_27_14 n_27_14 n_27_15 1k
Rh_27_15 n_27_15 n_27_16 1k
Rh_27_16 n_27_16 n_27_17 1k
Rh_27_17 n_27_17 n_27_18 1k
Rh_27_18 n_27_18 n_27_19 1k
Rh_27_19 n_27_19 n_27_20 1k
Rh_27_20 n_27_20 n_27_21 1k
Rh_27_21 n_27_21 n_27_22 1k
Rh_27_22 n_27_22 n_27_23 1k
Rh_27_23 n_27_23 n_27_24 1k
Rh_27_24 n_27_24 n_27_25 1k
Rh_27_25 n_27_25 n_27_26 1k
Rh_27_26 n_27_26 n_27_27 1k
Rh_27_27 n_27_27 n_27_28 1k
Rh_27_28 n_27_28 n_27_29 1k
Rh_27_29 n_27_29 n_27_30 1k
Rh_27_30 n_27_30 n_27_31 1k
Rh_27_31 n_27_31 n_27_32 1k
Rh_27_32 n_27_32 n_27_33 1k
Rh_27_33 n_27_33 n_27_34 1k
Rh_27_34 n_27_34 n_27_35 1k
Rh_27_35 n_27_35 n_27_36 1k
Rh_27_36 n_27_36 n_27_37 1k
Rh_27_37 n_27_37 n_27_38 1k

* Row 28
Rh_28_0 n_28_0 n_28_1 1k
Rh_28_1 n_28_1 n_28_2 1k
Rh_28_2 n_28_2 n_28_3 1k
Rh_28_3 n_28_3 n_28_4 1k
Rh_28_4 n_28_4 n_28_5 1k
Rh_28_5 n_28_5 n_28_6 1k
Rh_28_6 n_28_6 n_28_7 1k
Rh_28_7 n_28_7 n_28_8 1k
Rh_28_8 n_28_8 n_28_9 1k
Rh_28_9 n_28_9 n_28_10 1k
Rh_28_10 n_28_10 n_28_11 1k
Rh_28_11 n_28_11 n_28_12 1k
Rh_28_12 n_28_12 n_28_13 1k
Rh_28_13 n_28_13 n_28_14 1k
Rh_28_14 n_28_14 n_28_15 1k
Rh_28_15 n_28_15 n_28_16 1k
Rh_28_16 n_28_16 n_28_17 1k
Rh_28_17 n_28_17 n_28_18 1k
Rh_28_18 n_28_18 n_28_19 1k
Rh_28_19 n_28_19 n_28_20 1k
Rh_28_20 n_28_20 n_28_21 1k
Rh_28_21 n_28_21 n_28_22 1k
Rh_28_22 n_28_22 n_28_23 1k
Rh_28_23 n_28_23 n_28_24 1k
Rh_28_24 n_28_24 n_28_25 1k
Rh_28_25 n_28_25 n_28_26 1k
Rh_28_26 n_28_26 n_28_27 1k
Rh_28_27 n_28_27 n_28_28 1k
Rh_28_28 n_28_28 n_28_29 1k
Rh_28_29 n_28_29 n_28_30 1k
Rh_28_30 n_28_30 n_28_31 1k
Rh_28_31 n_28_31 n_28_32 1k
Rh_28_32 n_28_32 n_28_33 1k
Rh_28_33 n_28_33 n_28_34 1k
Rh_28_34 n_28_34 n_28_35 1k
Rh_28_35 n_28_35 n_28_36 1k
Rh_28_36 n_28_36 n_28_37 1k
Rh_28_37 n_28_37 n_28_38 1k

* Row 29
Rh_29_0 n_29_0 n_29_1 1k
Rh_29_1 n_29_1 n_29_2 1k
Rh_29_2 n_29_2 n_29_3 1k
Rh_29_3 n_29_3 n_29_4 1k
Rh_29_4 n_29_4 n_29_5 1k
Rh_29_5 n_29_5 n_29_6 1k
Rh_29_6 n_29_6 n_29_7 1k
Rh_29_7 n_29_7 n_29_8 1k
Rh_29_8 n_29_8 n_29_9 1k
Rh_29_9 n_29_9 n_29_10 1k
Rh_29_10 n_29_10 n_29_11 1k
Rh_29_11 n_29_11 n_29_12 1k
Rh_29_12 n_29_12 n_29_13 1k
Rh_29_13 n_29_13 n_29_14 1k
Rh_29_14 n_29_14 n_29_15 1k
Rh_29_15 n_29_15 n_29_16 1k
Rh_29_16 n_29_16 n_29_17 1k
Rh_29_17 n_29_17 n_29_18 1k
Rh_29_18 n_29_18 n_29_19 1k
Rh_29_19 n_29_19 n_29_20 1k
Rh_29_20 n_29_20 n_29_21 1k
Rh_29_21 n_29_21 n_29_22 1k
Rh_29_22 n_29_22 n_29_23 1k
Rh_29_23 n_29_23 n_29_24 1k
Rh_29_24 n_29_24 n_29_25 1k
Rh_29_25 n_29_25 n_29_26 1k
Rh_29_26 n_29_26 n_29_27 1k
Rh_29_27 n_29_27 n_29_28 1k
Rh_29_28 n_29_28 n_29_29 1k
Rh_29_29 n_29_29 n_29_30 1k
Rh_29_30 n_29_30 n_29_31 1k
Rh_29_31 n_29_31 n_29_32 1k
Rh_29_32 n_29_32 n_29_33 1k
Rh_29_33 n_29_33 n_29_34 1k
Rh_29_34 n_29_34 n_29_35 1k
Rh_29_35 n_29_35 n_29_36 1k
Rh_29_36 n_29_36 n_29_37 1k
Rh_29_37 n_29_37 n_29_38 1k

* Row 30
Rh_30_0 n_30_0 n_30_1 1k
Rh_30_1 n_30_1 n_30_2 1k
Rh_30_2 n_30_2 n_30_3 1k
Rh_30_3 n_30_3 n_30_4 1k
Rh_30_4 n_30_4 n_30_5 1k
Rh_30_5 n_30_5 n_30_6 1k
Rh_30_6 n_30_6 n_30_7 1k
Rh_30_7 n_30_7 n_30_8 1k
Rh_30_8 n_30_8 n_30_9 1k
Rh_30_9 n_30_9 n_30_10 1k
Rh_30_10 n_30_10 n_30_11 1k
Rh_30_11 n_30_11 n_30_12 1k
Rh_30_12 n_30_12 n_30_13 1k
Rh_30_13 n_30_13 n_30_14 1k
Rh_30_14 n_30_14 n_30_15 1k
Rh_30_15 n_30_15 n_30_16 1k
Rh_30_16 n_30_16 n_30_17 1k
Rh_30_17 n_30_17 n_30_18 1k
Rh_30_18 n_30_18 n_30_19 1k
Rh_30_19 n_30_19 n_30_20 1k
Rh_30_20 n_30_20 n_30_21 1k
Rh_30_21 n_30_21 n_30_22 1k
Rh_30_22 n_30_22 n_30_23 1k
Rh_30_23 n_30_23 n_30_24 1k
Rh_30_24 n_30_24 n_30_25 1k
Rh_30_25 n_30_25 n_30_26 1k
Rh_30_26 n_30_26 n_30_27 1k
Rh_30_27 n_30_27 n_30_28 1k
Rh_30_28 n_30_28 n_30_29 1k
Rh_30_29 n_30_29 n_30_30 1k
Rh_30_30 n_30_30 n_30_31 1k
Rh_30_31 n_30_31 n_30_32 1k
Rh_30_32 n_30_32 n_30_33 1k
Rh_30_33 n_30_33 n_30_34 1k
Rh_30_34 n_30_34 n_30_35 1k
Rh_30_35 n_30_35 n_30_36 1k
Rh_30_36 n_30_36 n_30_37 1k
Rh_30_37 n_30_37 n_30_38 1k

* Row 31
Rh_31_0 n_31_0 n_31_1 1k
Rh_31_1 n_31_1 n_31_2 1k
Rh_31_2 n_31_2 n_31_3 1k
Rh_31_3 n_31_3 n_31_4 1k
Rh_31_4 n_31_4 n_31_5 1k
Rh_31_5 n_31_5 n_31_6 1k
Rh_31_6 n_31_6 n_31_7 1k
Rh_31_7 n_31_7 n_31_8 1k
Rh_31_8 n_31_8 n_31_9 1k
Rh_31_9 n_31_9 n_31_10 1k
Rh_31_10 n_31_10 n_31_11 1k
Rh_31_11 n_31_11 n_31_12 1k
Rh_31_12 n_31_12 n_31_13 1k
Rh_31_13 n_31_13 n_31_14 1k
Rh_31_14 n_31_14 n_31_15 1k
Rh_31_15 n_31_15 n_31_16 1k
Rh_31_16 n_31_16 n_31_17 1k
Rh_31_17 n_31_17 n_31_18 1k
Rh_31_18 n_31_18 n_31_19 1k
Rh_31_19 n_31_19 n_31_20 1k
Rh_31_20 n_31_20 n_31_21 1k
Rh_31_21 n_31_21 n_31_22 1k
Rh_31_22 n_31_22 n_31_23 1k
Rh_31_23 n_31_23 n_31_24 1k
Rh_31_24 n_31_24 n_31_25 1k
Rh_31_25 n_31_25 n_31_26 1k
Rh_31_26 n_31_26 n_31_27 1k
Rh_31_27 n_31_27 n_31_28 1k
Rh_31_28 n_31_28 n_31_29 1k
Rh_31_29 n_31_29 n_31_30 1k
Rh_31_30 n_31_30 n_31_31 1k
Rh_31_31 n_31_31 n_31_32 1k
Rh_31_32 n_31_32 n_31_33 1k
Rh_31_33 n_31_33 n_31_34 1k
Rh_31_34 n_31_34 n_31_35 1k
Rh_31_35 n_31_35 n_31_36 1k
Rh_31_36 n_31_36 n_31_37 1k
Rh_31_37 n_31_37 n_31_38 1k

* Row 32
Rh_32_0 n_32_0 n_32_1 1k
Rh_32_1 n_32_1 n_32_2 1k
Rh_32_2 n_32_2 n_32_3 1k
Rh_32_3 n_32_3 n_32_4 1k
Rh_32_4 n_32_4 n_32_5 1k
Rh_32_5 n_32_5 n_32_6 1k
Rh_32_6 n_32_6 n_32_7 1k
Rh_32_7 n_32_7 n_32_8 1k
Rh_32_8 n_32_8 n_32_9 1k
Rh_32_9 n_32_9 n_32_10 1k
Rh_32_10 n_32_10 n_32_11 1k
Rh_32_11 n_32_11 n_32_12 1k
Rh_32_12 n_32_12 n_32_13 1k
Rh_32_13 n_32_13 n_32_14 1k
Rh_32_14 n_32_14 n_32_15 1k
Rh_32_15 n_32_15 n_32_16 1k
Rh_32_16 n_32_16 n_32_17 1k
Rh_32_17 n_32_17 n_32_18 1k
Rh_32_18 n_32_18 n_32_19 1k
Rh_32_19 n_32_19 n_32_20 1k
Rh_32_20 n_32_20 n_32_21 1k
Rh_32_21 n_32_21 n_32_22 1k
Rh_32_22 n_32_22 n_32_23 1k
Rh_32_23 n_32_23 n_32_24 1k
Rh_32_24 n_32_24 n_32_25 1k
Rh_32_25 n_32_25 n_32_26 1k
Rh_32_26 n_32_26 n_32_27 1k
Rh_32_27 n_32_27 n_32_28 1k
Rh_32_28 n_32_28 n_32_29 1k
Rh_32_29 n_32_29 n_32_30 1k
Rh_32_30 n_32_30 n_32_31 1k
Rh_32_31 n_32_31 n_32_32 1k
Rh_32_32 n_32_32 n_32_33 1k
Rh_32_33 n_32_33 n_32_34 1k
Rh_32_34 n_32_34 n_32_35 1k
Rh_32_35 n_32_35 n_32_36 1k
Rh_32_36 n_32_36 n_32_37 1k
Rh_32_37 n_32_37 n_32_38 1k

* Row 33
Rh_33_0 n_33_0 n_33_1 1k
Rh_33_1 n_33_1 n_33_2 1k
Rh_33_2 n_33_2 n_33_3 1k
Rh_33_3 n_33_3 n_33_4 1k
Rh_33_4 n_33_4 n_33_5 1k
Rh_33_5 n_33_5 n_33_6 1k
Rh_33_6 n_33_6 n_33_7 1k
Rh_33_7 n_33_7 n_33_8 1k
Rh_33_8 n_33_8 n_33_9 1k
Rh_33_9 n_33_9 n_33_10 1k
Rh_33_10 n_33_10 n_33_11 1k
Rh_33_11 n_33_11 n_33_12 1k
Rh_33_12 n_33_12 n_33_13 1k
Rh_33_13 n_33_13 n_33_14 1k
Rh_33_14 n_33_14 n_33_15 1k
Rh_33_15 n_33_15 n_33_16 1k
Rh_33_16 n_33_16 n_33_17 1k
Rh_33_17 n_33_17 n_33_18 1k
Rh_33_18 n_33_18 n_33_19 1k
Rh_33_19 n_33_19 n_33_20 1k
Rh_33_20 n_33_20 n_33_21 1k
Rh_33_21 n_33_21 n_33_22 1k
Rh_33_22 n_33_22 n_33_23 1k
Rh_33_23 n_33_23 n_33_24 1k
Rh_33_24 n_33_24 n_33_25 1k
Rh_33_25 n_33_25 n_33_26 1k
Rh_33_26 n_33_26 n_33_27 1k
Rh_33_27 n_33_27 n_33_28 1k
Rh_33_28 n_33_28 n_33_29 1k
Rh_33_29 n_33_29 n_33_30 1k
Rh_33_30 n_33_30 n_33_31 1k
Rh_33_31 n_33_31 n_33_32 1k
Rh_33_32 n_33_32 n_33_33 1k
Rh_33_33 n_33_33 n_33_34 1k
Rh_33_34 n_33_34 n_33_35 1k
Rh_33_35 n_33_35 n_33_36 1k
Rh_33_36 n_33_36 n_33_37 1k
Rh_33_37 n_33_37 n_33_38 1k

* Row 34
Rh_34_0 n_34_0 n_34_1 1k
Rh_34_1 n_34_1 n_34_2 1k
Rh_34_2 n_34_2 n_34_3 1k
Rh_34_3 n_34_3 n_34_4 1k
Rh_34_4 n_34_4 n_34_5 1k
Rh_34_5 n_34_5 n_34_6 1k
Rh_34_6 n_34_6 n_34_7 1k
Rh_34_7 n_34_7 n_34_8 1k
Rh_34_8 n_34_8 n_34_9 1k
Rh_34_9 n_34_9 n_34_10 1k
Rh_34_10 n_34_10 n_34_11 1k
Rh_34_11 n_34_11 n_34_12 1k
Rh_34_12 n_34_12 n_34_13 1k
Rh_34_13 n_34_13 n_34_14 1k
Rh_34_14 n_34_14 n_34_15 1k
Rh_34_15 n_34_15 n_34_16 1k
Rh_34_16 n_34_16 n_34_17 1k
Rh_34_17 n_34_17 n_34_18 1k
Rh_34_18 n_34_18 n_34_19 1k
Rh_34_19 n_34_19 n_34_20 1k
Rh_34_20 n_34_20 n_34_21 1k
Rh_34_21 n_34_21 n_34_22 1k
Rh_34_22 n_34_22 n_34_23 1k
Rh_34_23 n_34_23 n_34_24 1k
Rh_34_24 n_34_24 n_34_25 1k
Rh_34_25 n_34_25 n_34_26 1k
Rh_34_26 n_34_26 n_34_27 1k
Rh_34_27 n_34_27 n_34_28 1k
Rh_34_28 n_34_28 n_34_29 1k
Rh_34_29 n_34_29 n_34_30 1k
Rh_34_30 n_34_30 n_34_31 1k
Rh_34_31 n_34_31 n_34_32 1k
Rh_34_32 n_34_32 n_34_33 1k
Rh_34_33 n_34_33 n_34_34 1k
Rh_34_34 n_34_34 n_34_35 1k
Rh_34_35 n_34_35 n_34_36 1k
Rh_34_36 n_34_36 n_34_37 1k
Rh_34_37 n_34_37 n_34_38 1k

* Row 35
Rh_35_0 n_35_0 n_35_1 1k
Rh_35_1 n_35_1 n_35_2 1k
Rh_35_2 n_35_2 n_35_3 1k
Rh_35_3 n_35_3 n_35_4 1k
Rh_35_4 n_35_4 n_35_5 1k
Rh_35_5 n_35_5 n_35_6 1k
Rh_35_6 n_35_6 n_35_7 1k
Rh_35_7 n_35_7 n_35_8 1k
Rh_35_8 n_35_8 n_35_9 1k
Rh_35_9 n_35_9 n_35_10 1k
Rh_35_10 n_35_10 n_35_11 1k
Rh_35_11 n_35_11 n_35_12 1k
Rh_35_12 n_35_12 n_35_13 1k
Rh_35_13 n_35_13 n_35_14 1k
Rh_35_14 n_35_14 n_35_15 1k
Rh_35_15 n_35_15 n_35_16 1k
Rh_35_16 n_35_16 n_35_17 1k
Rh_35_17 n_35_17 n_35_18 1k
Rh_35_18 n_35_18 n_35_19 1k
Rh_35_19 n_35_19 n_35_20 1k
Rh_35_20 n_35_20 n_35_21 1k
Rh_35_21 n_35_21 n_35_22 1k
Rh_35_22 n_35_22 n_35_23 1k
Rh_35_23 n_35_23 n_35_24 1k
Rh_35_24 n_35_24 n_35_25 1k
Rh_35_25 n_35_25 n_35_26 1k
Rh_35_26 n_35_26 n_35_27 1k
Rh_35_27 n_35_27 n_35_28 1k
Rh_35_28 n_35_28 n_35_29 1k
Rh_35_29 n_35_29 n_35_30 1k
Rh_35_30 n_35_30 n_35_31 1k
Rh_35_31 n_35_31 n_35_32 1k
Rh_35_32 n_35_32 n_35_33 1k
Rh_35_33 n_35_33 n_35_34 1k
Rh_35_34 n_35_34 n_35_35 1k
Rh_35_35 n_35_35 n_35_36 1k
Rh_35_36 n_35_36 n_35_37 1k
Rh_35_37 n_35_37 n_35_38 1k

* Row 36
Rh_36_0 n_36_0 n_36_1 1k
Rh_36_1 n_36_1 n_36_2 1k
Rh_36_2 n_36_2 n_36_3 1k
Rh_36_3 n_36_3 n_36_4 1k
Rh_36_4 n_36_4 n_36_5 1k
Rh_36_5 n_36_5 n_36_6 1k
Rh_36_6 n_36_6 n_36_7 1k
Rh_36_7 n_36_7 n_36_8 1k
Rh_36_8 n_36_8 n_36_9 1k
Rh_36_9 n_36_9 n_36_10 1k
Rh_36_10 n_36_10 n_36_11 1k
Rh_36_11 n_36_11 n_36_12 1k
Rh_36_12 n_36_12 n_36_13 1k
Rh_36_13 n_36_13 n_36_14 1k
Rh_36_14 n_36_14 n_36_15 1k
Rh_36_15 n_36_15 n_36_16 1k
Rh_36_16 n_36_16 n_36_17 1k
Rh_36_17 n_36_17 n_36_18 1k
Rh_36_18 n_36_18 n_36_19 1k
Rh_36_19 n_36_19 n_36_20 1k
Rh_36_20 n_36_20 n_36_21 1k
Rh_36_21 n_36_21 n_36_22 1k
Rh_36_22 n_36_22 n_36_23 1k
Rh_36_23 n_36_23 n_36_24 1k
Rh_36_24 n_36_24 n_36_25 1k
Rh_36_25 n_36_25 n_36_26 1k
Rh_36_26 n_36_26 n_36_27 1k
Rh_36_27 n_36_27 n_36_28 1k
Rh_36_28 n_36_28 n_36_29 1k
Rh_36_29 n_36_29 n_36_30 1k
Rh_36_30 n_36_30 n_36_31 1k
Rh_36_31 n_36_31 n_36_32 1k
Rh_36_32 n_36_32 n_36_33 1k
Rh_36_33 n_36_33 n_36_34 1k
Rh_36_34 n_36_34 n_36_35 1k
Rh_36_35 n_36_35 n_36_36 1k
Rh_36_36 n_36_36 n_36_37 1k
Rh_36_37 n_36_37 n_36_38 1k

* Row 37
Rh_37_0 n_37_0 n_37_1 1k
Rh_37_1 n_37_1 n_37_2 1k
Rh_37_2 n_37_2 n_37_3 1k
Rh_37_3 n_37_3 n_37_4 1k
Rh_37_4 n_37_4 n_37_5 1k
Rh_37_5 n_37_5 n_37_6 1k
Rh_37_6 n_37_6 n_37_7 1k
Rh_37_7 n_37_7 n_37_8 1k
Rh_37_8 n_37_8 n_37_9 1k
Rh_37_9 n_37_9 n_37_10 1k
Rh_37_10 n_37_10 n_37_11 1k
Rh_37_11 n_37_11 n_37_12 1k
Rh_37_12 n_37_12 n_37_13 1k
Rh_37_13 n_37_13 n_37_14 1k
Rh_37_14 n_37_14 n_37_15 1k
Rh_37_15 n_37_15 n_37_16 1k
Rh_37_16 n_37_16 n_37_17 1k
Rh_37_17 n_37_17 n_37_18 1k
Rh_37_18 n_37_18 n_37_19 1k
Rh_37_19 n_37_19 n_37_20 1k
Rh_37_20 n_37_20 n_37_21 1k
Rh_37_21 n_37_21 n_37_22 1k
Rh_37_22 n_37_22 n_37_23 1k
Rh_37_23 n_37_23 n_37_24 1k
Rh_37_24 n_37_24 n_37_25 1k
Rh_37_25 n_37_25 n_37_26 1k
Rh_37_26 n_37_26 n_37_27 1k
Rh_37_27 n_37_27 n_37_28 1k
Rh_37_28 n_37_28 n_37_29 1k
Rh_37_29 n_37_29 n_37_30 1k
Rh_37_30 n_37_30 n_37_31 1k
Rh_37_31 n_37_31 n_37_32 1k
Rh_37_32 n_37_32 n_37_33 1k
Rh_37_33 n_37_33 n_37_34 1k
Rh_37_34 n_37_34 n_37_35 1k
Rh_37_35 n_37_35 n_37_36 1k
Rh_37_36 n_37_36 n_37_37 1k
Rh_37_37 n_37_37 n_37_38 1k

* Row 38
Rh_38_0 n_38_0 n_38_1 1k
Rh_38_1 n_38_1 n_38_2 1k
Rh_38_2 n_38_2 n_38_3 1k
Rh_38_3 n_38_3 n_38_4 1k
Rh_38_4 n_38_4 n_38_5 1k
Rh_38_5 n_38_5 n_38_6 1k
Rh_38_6 n_38_6 n_38_7 1k
Rh_38_7 n_38_7 n_38_8 1k
Rh_38_8 n_38_8 n_38_9 1k
Rh_38_9 n_38_9 n_38_10 1k
Rh_38_10 n_38_10 n_38_11 1k
Rh_38_11 n_38_11 n_38_12 1k
Rh_38_12 n_38_12 n_38_13 1k
Rh_38_13 n_38_13 n_38_14 1k
Rh_38_14 n_38_14 n_38_15 1k
Rh_38_15 n_38_15 n_38_16 1k
Rh_38_16 n_38_16 n_38_17 1k
Rh_38_17 n_38_17 n_38_18 1k
Rh_38_18 n_38_18 n_38_19 1k
Rh_38_19 n_38_19 n_38_20 1k
Rh_38_20 n_38_20 n_38_21 1k
Rh_38_21 n_38_21 n_38_22 1k
Rh_38_22 n_38_22 n_38_23 1k
Rh_38_23 n_38_23 n_38_24 1k
Rh_38_24 n_38_24 n_38_25 1k
Rh_38_25 n_38_25 n_38_26 1k
Rh_38_26 n_38_26 n_38_27 1k
Rh_38_27 n_38_27 n_38_28 1k
Rh_38_28 n_38_28 n_38_29 1k
Rh_38_29 n_38_29 n_38_30 1k
Rh_38_30 n_38_30 n_38_31 1k
Rh_38_31 n_38_31 n_38_32 1k
Rh_38_32 n_38_32 n_38_33 1k
Rh_38_33 n_38_33 n_38_34 1k
Rh_38_34 n_38_34 n_38_35 1k
Rh_38_35 n_38_35 n_38_36 1k
Rh_38_36 n_38_36 n_38_37 1k
Rh_38_37 n_38_37 n_38_38 1k

* Vertical resistors (Column 0)
Rv_0_0 n_0_0 n_1_0 1k
Rv_1_0 n_1_0 n_2_0 1k
Rv_2_0 n_2_0 n_3_0 1k
Rv_3_0 n_3_0 n_4_0 1k
Rv_4_0 n_4_0 n_5_0 1k
Rv_5_0 n_5_0 n_6_0 1k
Rv_6_0 n_6_0 n_7_0 1k
Rv_7_0 n_7_0 n_8_0 1k
Rv_8_0 n_8_0 n_9_0 1k
Rv_9_0 n_9_0 n_10_0 1k
Rv_10_0 n_10_0 n_11_0 1k
Rv_11_0 n_11_0 n_12_0 1k
Rv_12_0 n_12_0 n_13_0 1k
Rv_13_0 n_13_0 n_14_0 1k
Rv_14_0 n_14_0 n_15_0 1k
Rv_15_0 n_15_0 n_16_0 1k
Rv_16_0 n_16_0 n_17_0 1k
Rv_17_0 n_17_0 n_18_0 1k
Rv_18_0 n_18_0 n_19_0 1k
Rv_19_0 n_19_0 n_20_0 1k
Rv_20_0 n_20_0 n_21_0 1k
Rv_21_0 n_21_0 n_22_0 1k
Rv_22_0 n_22_0 n_23_0 1k
Rv_23_0 n_23_0 n_24_0 1k
Rv_24_0 n_24_0 n_25_0 1k
Rv_25_0 n_25_0 n_26_0 1k
Rv_26_0 n_26_0 n_27_0 1k
Rv_27_0 n_27_0 n_28_0 1k
Rv_28_0 n_28_0 n_29_0 1k
Rv_29_0 n_29_0 n_30_0 1k
Rv_30_0 n_30_0 n_31_0 1k
Rv_31_0 n_31_0 n_32_0 1k
Rv_32_0 n_32_0 n_33_0 1k
Rv_33_0 n_33_0 n_34_0 1k
Rv_34_0 n_34_0 n_35_0 1k
Rv_35_0 n_35_0 n_36_0 1k
Rv_36_0 n_36_0 n_37_0 1k
Rv_37_0 n_37_0 n_38_0 1k

* Vertical resistors (Column 1)
Rv_0_1 n_0_1 n_1_1 1k
Rv_1_1 n_1_1 n_2_1 1k
Rv_2_1 n_2_1 n_3_1 1k
Rv_3_1 n_3_1 n_4_1 1k
Rv_4_1 n_4_1 n_5_1 1k
Rv_5_1 n_5_1 n_6_1 1k
Rv_6_1 n_6_1 n_7_1 1k
Rv_7_1 n_7_1 n_8_1 1k
Rv_8_1 n_8_1 n_9_1 1k
Rv_9_1 n_9_1 n_10_1 1k
Rv_10_1 n_10_1 n_11_1 1k
Rv_11_1 n_11_1 n_12_1 1k
Rv_12_1 n_12_1 n_13_1 1k
Rv_13_1 n_13_1 n_14_1 1k
Rv_14_1 n_14_1 n_15_1 1k
Rv_15_1 n_15_1 n_16_1 1k
Rv_16_1 n_16_1 n_17_1 1k
Rv_17_1 n_17_1 n_18_1 1k
Rv_18_1 n_18_1 n_19_1 1k
Rv_19_1 n_19_1 n_20_1 1k
Rv_20_1 n_20_1 n_21_1 1k
Rv_21_1 n_21_1 n_22_1 1k
Rv_22_1 n_22_1 n_23_1 1k
Rv_23_1 n_23_1 n_24_1 1k
Rv_24_1 n_24_1 n_25_1 1k
Rv_25_1 n_25_1 n_26_1 1k
Rv_26_1 n_26_1 n_27_1 1k
Rv_27_1 n_27_1 n_28_1 1k
Rv_28_1 n_28_1 n_29_1 1k
Rv_29_1 n_29_1 n_30_1 1k
Rv_30_1 n_30_1 n_31_1 1k
Rv_31_1 n_31_1 n_32_1 1k
Rv_32_1 n_32_1 n_33_1 1k
Rv_33_1 n_33_1 n_34_1 1k
Rv_34_1 n_34_1 n_35_1 1k
Rv_35_1 n_35_1 n_36_1 1k
Rv_36_1 n_36_1 n_37_1 1k
Rv_37_1 n_37_1 n_38_1 1k

* Vertical resistors (Column 2)
Rv_0_2 n_0_2 n_1_2 1k
Rv_1_2 n_1_2 n_2_2 1k
Rv_2_2 n_2_2 n_3_2 1k
Rv_3_2 n_3_2 n_4_2 1k
Rv_4_2 n_4_2 n_5_2 1k
Rv_5_2 n_5_2 n_6_2 1k
Rv_6_2 n_6_2 n_7_2 1k
Rv_7_2 n_7_2 n_8_2 1k
Rv_8_2 n_8_2 n_9_2 1k
Rv_9_2 n_9_2 n_10_2 1k
Rv_10_2 n_10_2 n_11_2 1k
Rv_11_2 n_11_2 n_12_2 1k
Rv_12_2 n_12_2 n_13_2 1k
Rv_13_2 n_13_2 n_14_2 1k
Rv_14_2 n_14_2 n_15_2 1k
Rv_15_2 n_15_2 n_16_2 1k
Rv_16_2 n_16_2 n_17_2 1k
Rv_17_2 n_17_2 n_18_2 1k
Rv_18_2 n_18_2 n_19_2 1k
Rv_19_2 n_19_2 n_20_2 1k
Rv_20_2 n_20_2 n_21_2 1k
Rv_21_2 n_21_2 n_22_2 1k
Rv_22_2 n_22_2 n_23_2 1k
Rv_23_2 n_23_2 n_24_2 1k
Rv_24_2 n_24_2 n_25_2 1k
Rv_25_2 n_25_2 n_26_2 1k
Rv_26_2 n_26_2 n_27_2 1k
Rv_27_2 n_27_2 n_28_2 1k
Rv_28_2 n_28_2 n_29_2 1k
Rv_29_2 n_29_2 n_30_2 1k
Rv_30_2 n_30_2 n_31_2 1k
Rv_31_2 n_31_2 n_32_2 1k
Rv_32_2 n_32_2 n_33_2 1k
Rv_33_2 n_33_2 n_34_2 1k
Rv_34_2 n_34_2 n_35_2 1k
Rv_35_2 n_35_2 n_36_2 1k
Rv_36_2 n_36_2 n_37_2 1k
Rv_37_2 n_37_2 n_38_2 1k

* Vertical resistors (Column 3)
Rv_0_3 n_0_3 n_1_3 1k
Rv_1_3 n_1_3 n_2_3 1k
Rv_2_3 n_2_3 n_3_3 1k
Rv_3_3 n_3_3 n_4_3 1k
Rv_4_3 n_4_3 n_5_3 1k
Rv_5_3 n_5_3 n_6_3 1k
Rv_6_3 n_6_3 n_7_3 1k
Rv_7_3 n_7_3 n_8_3 1k
Rv_8_3 n_8_3 n_9_3 1k
Rv_9_3 n_9_3 n_10_3 1k
Rv_10_3 n_10_3 n_11_3 1k
Rv_11_3 n_11_3 n_12_3 1k
Rv_12_3 n_12_3 n_13_3 1k
Rv_13_3 n_13_3 n_14_3 1k
Rv_14_3 n_14_3 n_15_3 1k
Rv_15_3 n_15_3 n_16_3 1k
Rv_16_3 n_16_3 n_17_3 1k
Rv_17_3 n_17_3 n_18_3 1k
Rv_18_3 n_18_3 n_19_3 1k
Rv_19_3 n_19_3 n_20_3 1k
Rv_20_3 n_20_3 n_21_3 1k
Rv_21_3 n_21_3 n_22_3 1k
Rv_22_3 n_22_3 n_23_3 1k
Rv_23_3 n_23_3 n_24_3 1k
Rv_24_3 n_24_3 n_25_3 1k
Rv_25_3 n_25_3 n_26_3 1k
Rv_26_3 n_26_3 n_27_3 1k
Rv_27_3 n_27_3 n_28_3 1k
Rv_28_3 n_28_3 n_29_3 1k
Rv_29_3 n_29_3 n_30_3 1k
Rv_30_3 n_30_3 n_31_3 1k
Rv_31_3 n_31_3 n_32_3 1k
Rv_32_3 n_32_3 n_33_3 1k
Rv_33_3 n_33_3 n_34_3 1k
Rv_34_3 n_34_3 n_35_3 1k
Rv_35_3 n_35_3 n_36_3 1k
Rv_36_3 n_36_3 n_37_3 1k
Rv_37_3 n_37_3 n_38_3 1k

* Vertical resistors (Column 4)
Rv_0_4 n_0_4 n_1_4 1k
Rv_1_4 n_1_4 n_2_4 1k
Rv_2_4 n_2_4 n_3_4 1k
Rv_3_4 n_3_4 n_4_4 1k
Rv_4_4 n_4_4 n_5_4 1k
Rv_5_4 n_5_4 n_6_4 1k
Rv_6_4 n_6_4 n_7_4 1k
Rv_7_4 n_7_4 n_8_4 1k
Rv_8_4 n_8_4 n_9_4 1k
Rv_9_4 n_9_4 n_10_4 1k
Rv_10_4 n_10_4 n_11_4 1k
Rv_11_4 n_11_4 n_12_4 1k
Rv_12_4 n_12_4 n_13_4 1k
Rv_13_4 n_13_4 n_14_4 1k
Rv_14_4 n_14_4 n_15_4 1k
Rv_15_4 n_15_4 n_16_4 1k
Rv_16_4 n_16_4 n_17_4 1k
Rv_17_4 n_17_4 n_18_4 1k
Rv_18_4 n_18_4 n_19_4 1k
Rv_19_4 n_19_4 n_20_4 1k
Rv_20_4 n_20_4 n_21_4 1k
Rv_21_4 n_21_4 n_22_4 1k
Rv_22_4 n_22_4 n_23_4 1k
Rv_23_4 n_23_4 n_24_4 1k
Rv_24_4 n_24_4 n_25_4 1k
Rv_25_4 n_25_4 n_26_4 1k
Rv_26_4 n_26_4 n_27_4 1k
Rv_27_4 n_27_4 n_28_4 1k
Rv_28_4 n_28_4 n_29_4 1k
Rv_29_4 n_29_4 n_30_4 1k
Rv_30_4 n_30_4 n_31_4 1k
Rv_31_4 n_31_4 n_32_4 1k
Rv_32_4 n_32_4 n_33_4 1k
Rv_33_4 n_33_4 n_34_4 1k
Rv_34_4 n_34_4 n_35_4 1k
Rv_35_4 n_35_4 n_36_4 1k
Rv_36_4 n_36_4 n_37_4 1k
Rv_37_4 n_37_4 n_38_4 1k

* Vertical resistors (Column 5)
Rv_0_5 n_0_5 n_1_5 1k
Rv_1_5 n_1_5 n_2_5 1k
Rv_2_5 n_2_5 n_3_5 1k
Rv_3_5 n_3_5 n_4_5 1k
Rv_4_5 n_4_5 n_5_5 1k
Rv_5_5 n_5_5 n_6_5 1k
Rv_6_5 n_6_5 n_7_5 1k
Rv_7_5 n_7_5 n_8_5 1k
Rv_8_5 n_8_5 n_9_5 1k
Rv_9_5 n_9_5 n_10_5 1k
Rv_10_5 n_10_5 n_11_5 1k
Rv_11_5 n_11_5 n_12_5 1k
Rv_12_5 n_12_5 n_13_5 1k
Rv_13_5 n_13_5 n_14_5 1k
Rv_14_5 n_14_5 n_15_5 1k
Rv_15_5 n_15_5 n_16_5 1k
Rv_16_5 n_16_5 n_17_5 1k
Rv_17_5 n_17_5 n_18_5 1k
Rv_18_5 n_18_5 n_19_5 1k
Rv_19_5 n_19_5 n_20_5 1k
Rv_20_5 n_20_5 n_21_5 1k
Rv_21_5 n_21_5 n_22_5 1k
Rv_22_5 n_22_5 n_23_5 1k
Rv_23_5 n_23_5 n_24_5 1k
Rv_24_5 n_24_5 n_25_5 1k
Rv_25_5 n_25_5 n_26_5 1k
Rv_26_5 n_26_5 n_27_5 1k
Rv_27_5 n_27_5 n_28_5 1k
Rv_28_5 n_28_5 n_29_5 1k
Rv_29_5 n_29_5 n_30_5 1k
Rv_30_5 n_30_5 n_31_5 1k
Rv_31_5 n_31_5 n_32_5 1k
Rv_32_5 n_32_5 n_33_5 1k
Rv_33_5 n_33_5 n_34_5 1k
Rv_34_5 n_34_5 n_35_5 1k
Rv_35_5 n_35_5 n_36_5 1k
Rv_36_5 n_36_5 n_37_5 1k
Rv_37_5 n_37_5 n_38_5 1k

* Vertical resistors (Column 6)
Rv_0_6 n_0_6 n_1_6 1k
Rv_1_6 n_1_6 n_2_6 1k
Rv_2_6 n_2_6 n_3_6 1k
Rv_3_6 n_3_6 n_4_6 1k
Rv_4_6 n_4_6 n_5_6 1k
Rv_5_6 n_5_6 n_6_6 1k
Rv_6_6 n_6_6 n_7_6 1k
Rv_7_6 n_7_6 n_8_6 1k
Rv_8_6 n_8_6 n_9_6 1k
Rv_9_6 n_9_6 n_10_6 1k
Rv_10_6 n_10_6 n_11_6 1k
Rv_11_6 n_11_6 n_12_6 1k
Rv_12_6 n_12_6 n_13_6 1k
Rv_13_6 n_13_6 n_14_6 1k
Rv_14_6 n_14_6 n_15_6 1k
Rv_15_6 n_15_6 n_16_6 1k
Rv_16_6 n_16_6 n_17_6 1k
Rv_17_6 n_17_6 n_18_6 1k
Rv_18_6 n_18_6 n_19_6 1k
Rv_19_6 n_19_6 n_20_6 1k
Rv_20_6 n_20_6 n_21_6 1k
Rv_21_6 n_21_6 n_22_6 1k
Rv_22_6 n_22_6 n_23_6 1k
Rv_23_6 n_23_6 n_24_6 1k
Rv_24_6 n_24_6 n_25_6 1k
Rv_25_6 n_25_6 n_26_6 1k
Rv_26_6 n_26_6 n_27_6 1k
Rv_27_6 n_27_6 n_28_6 1k
Rv_28_6 n_28_6 n_29_6 1k
Rv_29_6 n_29_6 n_30_6 1k
Rv_30_6 n_30_6 n_31_6 1k
Rv_31_6 n_31_6 n_32_6 1k
Rv_32_6 n_32_6 n_33_6 1k
Rv_33_6 n_33_6 n_34_6 1k
Rv_34_6 n_34_6 n_35_6 1k
Rv_35_6 n_35_6 n_36_6 1k
Rv_36_6 n_36_6 n_37_6 1k
Rv_37_6 n_37_6 n_38_6 1k

* Vertical resistors (Column 7)
Rv_0_7 n_0_7 n_1_7 1k
Rv_1_7 n_1_7 n_2_7 1k
Rv_2_7 n_2_7 n_3_7 1k
Rv_3_7 n_3_7 n_4_7 1k
Rv_4_7 n_4_7 n_5_7 1k
Rv_5_7 n_5_7 n_6_7 1k
Rv_6_7 n_6_7 n_7_7 1k
Rv_7_7 n_7_7 n_8_7 1k
Rv_8_7 n_8_7 n_9_7 1k
Rv_9_7 n_9_7 n_10_7 1k
Rv_10_7 n_10_7 n_11_7 1k
Rv_11_7 n_11_7 n_12_7 1k
Rv_12_7 n_12_7 n_13_7 1k
Rv_13_7 n_13_7 n_14_7 1k
Rv_14_7 n_14_7 n_15_7 1k
Rv_15_7 n_15_7 n_16_7 1k
Rv_16_7 n_16_7 n_17_7 1k
Rv_17_7 n_17_7 n_18_7 1k
Rv_18_7 n_18_7 n_19_7 1k
Rv_19_7 n_19_7 n_20_7 1k
Rv_20_7 n_20_7 n_21_7 1k
Rv_21_7 n_21_7 n_22_7 1k
Rv_22_7 n_22_7 n_23_7 1k
Rv_23_7 n_23_7 n_24_7 1k
Rv_24_7 n_24_7 n_25_7 1k
Rv_25_7 n_25_7 n_26_7 1k
Rv_26_7 n_26_7 n_27_7 1k
Rv_27_7 n_27_7 n_28_7 1k
Rv_28_7 n_28_7 n_29_7 1k
Rv_29_7 n_29_7 n_30_7 1k
Rv_30_7 n_30_7 n_31_7 1k
Rv_31_7 n_31_7 n_32_7 1k
Rv_32_7 n_32_7 n_33_7 1k
Rv_33_7 n_33_7 n_34_7 1k
Rv_34_7 n_34_7 n_35_7 1k
Rv_35_7 n_35_7 n_36_7 1k
Rv_36_7 n_36_7 n_37_7 1k
Rv_37_7 n_37_7 n_38_7 1k

* Vertical resistors (Column 8)
Rv_0_8 n_0_8 n_1_8 1k
Rv_1_8 n_1_8 n_2_8 1k
Rv_2_8 n_2_8 n_3_8 1k
Rv_3_8 n_3_8 n_4_8 1k
Rv_4_8 n_4_8 n_5_8 1k
Rv_5_8 n_5_8 n_6_8 1k
Rv_6_8 n_6_8 n_7_8 1k
Rv_7_8 n_7_8 n_8_8 1k
Rv_8_8 n_8_8 n_9_8 1k
Rv_9_8 n_9_8 n_10_8 1k
Rv_10_8 n_10_8 n_11_8 1k
Rv_11_8 n_11_8 n_12_8 1k
Rv_12_8 n_12_8 n_13_8 1k
Rv_13_8 n_13_8 n_14_8 1k
Rv_14_8 n_14_8 n_15_8 1k
Rv_15_8 n_15_8 n_16_8 1k
Rv_16_8 n_16_8 n_17_8 1k
Rv_17_8 n_17_8 n_18_8 1k
Rv_18_8 n_18_8 n_19_8 1k
Rv_19_8 n_19_8 n_20_8 1k
Rv_20_8 n_20_8 n_21_8 1k
Rv_21_8 n_21_8 n_22_8 1k
Rv_22_8 n_22_8 n_23_8 1k
Rv_23_8 n_23_8 n_24_8 1k
Rv_24_8 n_24_8 n_25_8 1k
Rv_25_8 n_25_8 n_26_8 1k
Rv_26_8 n_26_8 n_27_8 1k
Rv_27_8 n_27_8 n_28_8 1k
Rv_28_8 n_28_8 n_29_8 1k
Rv_29_8 n_29_8 n_30_8 1k
Rv_30_8 n_30_8 n_31_8 1k
Rv_31_8 n_31_8 n_32_8 1k
Rv_32_8 n_32_8 n_33_8 1k
Rv_33_8 n_33_8 n_34_8 1k
Rv_34_8 n_34_8 n_35_8 1k
Rv_35_8 n_35_8 n_36_8 1k
Rv_36_8 n_36_8 n_37_8 1k
Rv_37_8 n_37_8 n_38_8 1k

* Vertical resistors (Column 9)
Rv_0_9 n_0_9 n_1_9 1k
Rv_1_9 n_1_9 n_2_9 1k
Rv_2_9 n_2_9 n_3_9 1k
Rv_3_9 n_3_9 n_4_9 1k
Rv_4_9 n_4_9 n_5_9 1k
Rv_5_9 n_5_9 n_6_9 1k
Rv_6_9 n_6_9 n_7_9 1k
Rv_7_9 n_7_9 n_8_9 1k
Rv_8_9 n_8_9 n_9_9 1k
Rv_9_9 n_9_9 n_10_9 1k
Rv_10_9 n_10_9 n_11_9 1k
Rv_11_9 n_11_9 n_12_9 1k
Rv_12_9 n_12_9 n_13_9 1k
Rv_13_9 n_13_9 n_14_9 1k
Rv_14_9 n_14_9 n_15_9 1k
Rv_15_9 n_15_9 n_16_9 1k
Rv_16_9 n_16_9 n_17_9 1k
Rv_17_9 n_17_9 n_18_9 1k
Rv_18_9 n_18_9 n_19_9 1k
Rv_19_9 n_19_9 n_20_9 1k
Rv_20_9 n_20_9 n_21_9 1k
Rv_21_9 n_21_9 n_22_9 1k
Rv_22_9 n_22_9 n_23_9 1k
Rv_23_9 n_23_9 n_24_9 1k
Rv_24_9 n_24_9 n_25_9 1k
Rv_25_9 n_25_9 n_26_9 1k
Rv_26_9 n_26_9 n_27_9 1k
Rv_27_9 n_27_9 n_28_9 1k
Rv_28_9 n_28_9 n_29_9 1k
Rv_29_9 n_29_9 n_30_9 1k
Rv_30_9 n_30_9 n_31_9 1k
Rv_31_9 n_31_9 n_32_9 1k
Rv_32_9 n_32_9 n_33_9 1k
Rv_33_9 n_33_9 n_34_9 1k
Rv_34_9 n_34_9 n_35_9 1k
Rv_35_9 n_35_9 n_36_9 1k
Rv_36_9 n_36_9 n_37_9 1k
Rv_37_9 n_37_9 n_38_9 1k

* Vertical resistors (Column 10)
Rv_0_10 n_0_10 n_1_10 1k
Rv_1_10 n_1_10 n_2_10 1k
Rv_2_10 n_2_10 n_3_10 1k
Rv_3_10 n_3_10 n_4_10 1k
Rv_4_10 n_4_10 n_5_10 1k
Rv_5_10 n_5_10 n_6_10 1k
Rv_6_10 n_6_10 n_7_10 1k
Rv_7_10 n_7_10 n_8_10 1k
Rv_8_10 n_8_10 n_9_10 1k
Rv_9_10 n_9_10 n_10_10 1k
Rv_10_10 n_10_10 n_11_10 1k
Rv_11_10 n_11_10 n_12_10 1k
Rv_12_10 n_12_10 n_13_10 1k
Rv_13_10 n_13_10 n_14_10 1k
Rv_14_10 n_14_10 n_15_10 1k
Rv_15_10 n_15_10 n_16_10 1k
Rv_16_10 n_16_10 n_17_10 1k
Rv_17_10 n_17_10 n_18_10 1k
Rv_18_10 n_18_10 n_19_10 1k
Rv_19_10 n_19_10 n_20_10 1k
Rv_20_10 n_20_10 n_21_10 1k
Rv_21_10 n_21_10 n_22_10 1k
Rv_22_10 n_22_10 n_23_10 1k
Rv_23_10 n_23_10 n_24_10 1k
Rv_24_10 n_24_10 n_25_10 1k
Rv_25_10 n_25_10 n_26_10 1k
Rv_26_10 n_26_10 n_27_10 1k
Rv_27_10 n_27_10 n_28_10 1k
Rv_28_10 n_28_10 n_29_10 1k
Rv_29_10 n_29_10 n_30_10 1k
Rv_30_10 n_30_10 n_31_10 1k
Rv_31_10 n_31_10 n_32_10 1k
Rv_32_10 n_32_10 n_33_10 1k
Rv_33_10 n_33_10 n_34_10 1k
Rv_34_10 n_34_10 n_35_10 1k
Rv_35_10 n_35_10 n_36_10 1k
Rv_36_10 n_36_10 n_37_10 1k
Rv_37_10 n_37_10 n_38_10 1k

* Vertical resistors (Column 11)
Rv_0_11 n_0_11 n_1_11 1k
Rv_1_11 n_1_11 n_2_11 1k
Rv_2_11 n_2_11 n_3_11 1k
Rv_3_11 n_3_11 n_4_11 1k
Rv_4_11 n_4_11 n_5_11 1k
Rv_5_11 n_5_11 n_6_11 1k
Rv_6_11 n_6_11 n_7_11 1k
Rv_7_11 n_7_11 n_8_11 1k
Rv_8_11 n_8_11 n_9_11 1k
Rv_9_11 n_9_11 n_10_11 1k
Rv_10_11 n_10_11 n_11_11 1k
Rv_11_11 n_11_11 n_12_11 1k
Rv_12_11 n_12_11 n_13_11 1k
Rv_13_11 n_13_11 n_14_11 1k
Rv_14_11 n_14_11 n_15_11 1k
Rv_15_11 n_15_11 n_16_11 1k
Rv_16_11 n_16_11 n_17_11 1k
Rv_17_11 n_17_11 n_18_11 1k
Rv_18_11 n_18_11 n_19_11 1k
Rv_19_11 n_19_11 n_20_11 1k
Rv_20_11 n_20_11 n_21_11 1k
Rv_21_11 n_21_11 n_22_11 1k
Rv_22_11 n_22_11 n_23_11 1k
Rv_23_11 n_23_11 n_24_11 1k
Rv_24_11 n_24_11 n_25_11 1k
Rv_25_11 n_25_11 n_26_11 1k
Rv_26_11 n_26_11 n_27_11 1k
Rv_27_11 n_27_11 n_28_11 1k
Rv_28_11 n_28_11 n_29_11 1k
Rv_29_11 n_29_11 n_30_11 1k
Rv_30_11 n_30_11 n_31_11 1k
Rv_31_11 n_31_11 n_32_11 1k
Rv_32_11 n_32_11 n_33_11 1k
Rv_33_11 n_33_11 n_34_11 1k
Rv_34_11 n_34_11 n_35_11 1k
Rv_35_11 n_35_11 n_36_11 1k
Rv_36_11 n_36_11 n_37_11 1k
Rv_37_11 n_37_11 n_38_11 1k

* Vertical resistors (Column 12)
Rv_0_12 n_0_12 n_1_12 1k
Rv_1_12 n_1_12 n_2_12 1k
Rv_2_12 n_2_12 n_3_12 1k
Rv_3_12 n_3_12 n_4_12 1k
Rv_4_12 n_4_12 n_5_12 1k
Rv_5_12 n_5_12 n_6_12 1k
Rv_6_12 n_6_12 n_7_12 1k
Rv_7_12 n_7_12 n_8_12 1k
Rv_8_12 n_8_12 n_9_12 1k
Rv_9_12 n_9_12 n_10_12 1k
Rv_10_12 n_10_12 n_11_12 1k
Rv_11_12 n_11_12 n_12_12 1k
Rv_12_12 n_12_12 n_13_12 1k
Rv_13_12 n_13_12 n_14_12 1k
Rv_14_12 n_14_12 n_15_12 1k
Rv_15_12 n_15_12 n_16_12 1k
Rv_16_12 n_16_12 n_17_12 1k
Rv_17_12 n_17_12 n_18_12 1k
Rv_18_12 n_18_12 n_19_12 1k
Rv_19_12 n_19_12 n_20_12 1k
Rv_20_12 n_20_12 n_21_12 1k
Rv_21_12 n_21_12 n_22_12 1k
Rv_22_12 n_22_12 n_23_12 1k
Rv_23_12 n_23_12 n_24_12 1k
Rv_24_12 n_24_12 n_25_12 1k
Rv_25_12 n_25_12 n_26_12 1k
Rv_26_12 n_26_12 n_27_12 1k
Rv_27_12 n_27_12 n_28_12 1k
Rv_28_12 n_28_12 n_29_12 1k
Rv_29_12 n_29_12 n_30_12 1k
Rv_30_12 n_30_12 n_31_12 1k
Rv_31_12 n_31_12 n_32_12 1k
Rv_32_12 n_32_12 n_33_12 1k
Rv_33_12 n_33_12 n_34_12 1k
Rv_34_12 n_34_12 n_35_12 1k
Rv_35_12 n_35_12 n_36_12 1k
Rv_36_12 n_36_12 n_37_12 1k
Rv_37_12 n_37_12 n_38_12 1k

* Vertical resistors (Column 13)
Rv_0_13 n_0_13 n_1_13 1k
Rv_1_13 n_1_13 n_2_13 1k
Rv_2_13 n_2_13 n_3_13 1k
Rv_3_13 n_3_13 n_4_13 1k
Rv_4_13 n_4_13 n_5_13 1k
Rv_5_13 n_5_13 n_6_13 1k
Rv_6_13 n_6_13 n_7_13 1k
Rv_7_13 n_7_13 n_8_13 1k
Rv_8_13 n_8_13 n_9_13 1k
Rv_9_13 n_9_13 n_10_13 1k
Rv_10_13 n_10_13 n_11_13 1k
Rv_11_13 n_11_13 n_12_13 1k
Rv_12_13 n_12_13 n_13_13 1k
Rv_13_13 n_13_13 n_14_13 1k
Rv_14_13 n_14_13 n_15_13 1k
Rv_15_13 n_15_13 n_16_13 1k
Rv_16_13 n_16_13 n_17_13 1k
Rv_17_13 n_17_13 n_18_13 1k
Rv_18_13 n_18_13 n_19_13 1k
Rv_19_13 n_19_13 n_20_13 1k
Rv_20_13 n_20_13 n_21_13 1k
Rv_21_13 n_21_13 n_22_13 1k
Rv_22_13 n_22_13 n_23_13 1k
Rv_23_13 n_23_13 n_24_13 1k
Rv_24_13 n_24_13 n_25_13 1k
Rv_25_13 n_25_13 n_26_13 1k
Rv_26_13 n_26_13 n_27_13 1k
Rv_27_13 n_27_13 n_28_13 1k
Rv_28_13 n_28_13 n_29_13 1k
Rv_29_13 n_29_13 n_30_13 1k
Rv_30_13 n_30_13 n_31_13 1k
Rv_31_13 n_31_13 n_32_13 1k
Rv_32_13 n_32_13 n_33_13 1k
Rv_33_13 n_33_13 n_34_13 1k
Rv_34_13 n_34_13 n_35_13 1k
Rv_35_13 n_35_13 n_36_13 1k
Rv_36_13 n_36_13 n_37_13 1k
Rv_37_13 n_37_13 n_38_13 1k

* Vertical resistors (Column 14)
Rv_0_14 n_0_14 n_1_14 1k
Rv_1_14 n_1_14 n_2_14 1k
Rv_2_14 n_2_14 n_3_14 1k
Rv_3_14 n_3_14 n_4_14 1k
Rv_4_14 n_4_14 n_5_14 1k
Rv_5_14 n_5_14 n_6_14 1k
Rv_6_14 n_6_14 n_7_14 1k
Rv_7_14 n_7_14 n_8_14 1k
Rv_8_14 n_8_14 n_9_14 1k
Rv_9_14 n_9_14 n_10_14 1k
Rv_10_14 n_10_14 n_11_14 1k
Rv_11_14 n_11_14 n_12_14 1k
Rv_12_14 n_12_14 n_13_14 1k
Rv_13_14 n_13_14 n_14_14 1k
Rv_14_14 n_14_14 n_15_14 1k
Rv_15_14 n_15_14 n_16_14 1k
Rv_16_14 n_16_14 n_17_14 1k
Rv_17_14 n_17_14 n_18_14 1k
Rv_18_14 n_18_14 n_19_14 1k
Rv_19_14 n_19_14 n_20_14 1k
Rv_20_14 n_20_14 n_21_14 1k
Rv_21_14 n_21_14 n_22_14 1k
Rv_22_14 n_22_14 n_23_14 1k
Rv_23_14 n_23_14 n_24_14 1k
Rv_24_14 n_24_14 n_25_14 1k
Rv_25_14 n_25_14 n_26_14 1k
Rv_26_14 n_26_14 n_27_14 1k
Rv_27_14 n_27_14 n_28_14 1k
Rv_28_14 n_28_14 n_29_14 1k
Rv_29_14 n_29_14 n_30_14 1k
Rv_30_14 n_30_14 n_31_14 1k
Rv_31_14 n_31_14 n_32_14 1k
Rv_32_14 n_32_14 n_33_14 1k
Rv_33_14 n_33_14 n_34_14 1k
Rv_34_14 n_34_14 n_35_14 1k
Rv_35_14 n_35_14 n_36_14 1k
Rv_36_14 n_36_14 n_37_14 1k
Rv_37_14 n_37_14 n_38_14 1k

* Vertical resistors (Column 15)
Rv_0_15 n_0_15 n_1_15 1k
Rv_1_15 n_1_15 n_2_15 1k
Rv_2_15 n_2_15 n_3_15 1k
Rv_3_15 n_3_15 n_4_15 1k
Rv_4_15 n_4_15 n_5_15 1k
Rv_5_15 n_5_15 n_6_15 1k
Rv_6_15 n_6_15 n_7_15 1k
Rv_7_15 n_7_15 n_8_15 1k
Rv_8_15 n_8_15 n_9_15 1k
Rv_9_15 n_9_15 n_10_15 1k
Rv_10_15 n_10_15 n_11_15 1k
Rv_11_15 n_11_15 n_12_15 1k
Rv_12_15 n_12_15 n_13_15 1k
Rv_13_15 n_13_15 n_14_15 1k
Rv_14_15 n_14_15 n_15_15 1k
Rv_15_15 n_15_15 n_16_15 1k
Rv_16_15 n_16_15 n_17_15 1k
Rv_17_15 n_17_15 n_18_15 1k
Rv_18_15 n_18_15 n_19_15 1k
Rv_19_15 n_19_15 n_20_15 1k
Rv_20_15 n_20_15 n_21_15 1k
Rv_21_15 n_21_15 n_22_15 1k
Rv_22_15 n_22_15 n_23_15 1k
Rv_23_15 n_23_15 n_24_15 1k
Rv_24_15 n_24_15 n_25_15 1k
Rv_25_15 n_25_15 n_26_15 1k
Rv_26_15 n_26_15 n_27_15 1k
Rv_27_15 n_27_15 n_28_15 1k
Rv_28_15 n_28_15 n_29_15 1k
Rv_29_15 n_29_15 n_30_15 1k
Rv_30_15 n_30_15 n_31_15 1k
Rv_31_15 n_31_15 n_32_15 1k
Rv_32_15 n_32_15 n_33_15 1k
Rv_33_15 n_33_15 n_34_15 1k
Rv_34_15 n_34_15 n_35_15 1k
Rv_35_15 n_35_15 n_36_15 1k
Rv_36_15 n_36_15 n_37_15 1k
Rv_37_15 n_37_15 n_38_15 1k

* Vertical resistors (Column 16)
Rv_0_16 n_0_16 n_1_16 1k
Rv_1_16 n_1_16 n_2_16 1k
Rv_2_16 n_2_16 n_3_16 1k
Rv_3_16 n_3_16 n_4_16 1k
Rv_4_16 n_4_16 n_5_16 1k
Rv_5_16 n_5_16 n_6_16 1k
Rv_6_16 n_6_16 n_7_16 1k
Rv_7_16 n_7_16 n_8_16 1k
Rv_8_16 n_8_16 n_9_16 1k
Rv_9_16 n_9_16 n_10_16 1k
Rv_10_16 n_10_16 n_11_16 1k
Rv_11_16 n_11_16 n_12_16 1k
Rv_12_16 n_12_16 n_13_16 1k
Rv_13_16 n_13_16 n_14_16 1k
Rv_14_16 n_14_16 n_15_16 1k
Rv_15_16 n_15_16 n_16_16 1k
Rv_16_16 n_16_16 n_17_16 1k
Rv_17_16 n_17_16 n_18_16 1k
Rv_18_16 n_18_16 n_19_16 1k
Rv_19_16 n_19_16 n_20_16 1k
Rv_20_16 n_20_16 n_21_16 1k
Rv_21_16 n_21_16 n_22_16 1k
Rv_22_16 n_22_16 n_23_16 1k
Rv_23_16 n_23_16 n_24_16 1k
Rv_24_16 n_24_16 n_25_16 1k
Rv_25_16 n_25_16 n_26_16 1k
Rv_26_16 n_26_16 n_27_16 1k
Rv_27_16 n_27_16 n_28_16 1k
Rv_28_16 n_28_16 n_29_16 1k
Rv_29_16 n_29_16 n_30_16 1k
Rv_30_16 n_30_16 n_31_16 1k
Rv_31_16 n_31_16 n_32_16 1k
Rv_32_16 n_32_16 n_33_16 1k
Rv_33_16 n_33_16 n_34_16 1k
Rv_34_16 n_34_16 n_35_16 1k
Rv_35_16 n_35_16 n_36_16 1k
Rv_36_16 n_36_16 n_37_16 1k
Rv_37_16 n_37_16 n_38_16 1k

* Vertical resistors (Column 17)
Rv_0_17 n_0_17 n_1_17 1k
Rv_1_17 n_1_17 n_2_17 1k
Rv_2_17 n_2_17 n_3_17 1k
Rv_3_17 n_3_17 n_4_17 1k
Rv_4_17 n_4_17 n_5_17 1k
Rv_5_17 n_5_17 n_6_17 1k
Rv_6_17 n_6_17 n_7_17 1k
Rv_7_17 n_7_17 n_8_17 1k
Rv_8_17 n_8_17 n_9_17 1k
Rv_9_17 n_9_17 n_10_17 1k
Rv_10_17 n_10_17 n_11_17 1k
Rv_11_17 n_11_17 n_12_17 1k
Rv_12_17 n_12_17 n_13_17 1k
Rv_13_17 n_13_17 n_14_17 1k
Rv_14_17 n_14_17 n_15_17 1k
Rv_15_17 n_15_17 n_16_17 1k
Rv_16_17 n_16_17 n_17_17 1k
Rv_17_17 n_17_17 n_18_17 1k
Rv_18_17 n_18_17 n_19_17 1k
Rv_19_17 n_19_17 n_20_17 1k
Rv_20_17 n_20_17 n_21_17 1k
Rv_21_17 n_21_17 n_22_17 1k
Rv_22_17 n_22_17 n_23_17 1k
Rv_23_17 n_23_17 n_24_17 1k
Rv_24_17 n_24_17 n_25_17 1k
Rv_25_17 n_25_17 n_26_17 1k
Rv_26_17 n_26_17 n_27_17 1k
Rv_27_17 n_27_17 n_28_17 1k
Rv_28_17 n_28_17 n_29_17 1k
Rv_29_17 n_29_17 n_30_17 1k
Rv_30_17 n_30_17 n_31_17 1k
Rv_31_17 n_31_17 n_32_17 1k
Rv_32_17 n_32_17 n_33_17 1k
Rv_33_17 n_33_17 n_34_17 1k
Rv_34_17 n_34_17 n_35_17 1k
Rv_35_17 n_35_17 n_36_17 1k
Rv_36_17 n_36_17 n_37_17 1k
Rv_37_17 n_37_17 n_38_17 1k

* Vertical resistors (Column 18)
Rv_0_18 n_0_18 n_1_18 1k
Rv_1_18 n_1_18 n_2_18 1k
Rv_2_18 n_2_18 n_3_18 1k
Rv_3_18 n_3_18 n_4_18 1k
Rv_4_18 n_4_18 n_5_18 1k
Rv_5_18 n_5_18 n_6_18 1k
Rv_6_18 n_6_18 n_7_18 1k
Rv_7_18 n_7_18 n_8_18 1k
Rv_8_18 n_8_18 n_9_18 1k
Rv_9_18 n_9_18 n_10_18 1k
Rv_10_18 n_10_18 n_11_18 1k
Rv_11_18 n_11_18 n_12_18 1k
Rv_12_18 n_12_18 n_13_18 1k
Rv_13_18 n_13_18 n_14_18 1k
Rv_14_18 n_14_18 n_15_18 1k
Rv_15_18 n_15_18 n_16_18 1k
Rv_16_18 n_16_18 n_17_18 1k
Rv_17_18 n_17_18 n_18_18 1k
Rv_18_18 n_18_18 n_19_18 1k
Rv_19_18 n_19_18 n_20_18 1k
Rv_20_18 n_20_18 n_21_18 1k
Rv_21_18 n_21_18 n_22_18 1k
Rv_22_18 n_22_18 n_23_18 1k
Rv_23_18 n_23_18 n_24_18 1k
Rv_24_18 n_24_18 n_25_18 1k
Rv_25_18 n_25_18 n_26_18 1k
Rv_26_18 n_26_18 n_27_18 1k
Rv_27_18 n_27_18 n_28_18 1k
Rv_28_18 n_28_18 n_29_18 1k
Rv_29_18 n_29_18 n_30_18 1k
Rv_30_18 n_30_18 n_31_18 1k
Rv_31_18 n_31_18 n_32_18 1k
Rv_32_18 n_32_18 n_33_18 1k
Rv_33_18 n_33_18 n_34_18 1k
Rv_34_18 n_34_18 n_35_18 1k
Rv_35_18 n_35_18 n_36_18 1k
Rv_36_18 n_36_18 n_37_18 1k
Rv_37_18 n_37_18 n_38_18 1k

* Vertical resistors (Column 19)
Rv_0_19 n_0_19 n_1_19 1k
Rv_1_19 n_1_19 n_2_19 1k
Rv_2_19 n_2_19 n_3_19 1k
Rv_3_19 n_3_19 n_4_19 1k
Rv_4_19 n_4_19 n_5_19 1k
Rv_5_19 n_5_19 n_6_19 1k
Rv_6_19 n_6_19 n_7_19 1k
Rv_7_19 n_7_19 n_8_19 1k
Rv_8_19 n_8_19 n_9_19 1k
Rv_9_19 n_9_19 n_10_19 1k
Rv_10_19 n_10_19 n_11_19 1k
Rv_11_19 n_11_19 n_12_19 1k
Rv_12_19 n_12_19 n_13_19 1k
Rv_13_19 n_13_19 n_14_19 1k
Rv_14_19 n_14_19 n_15_19 1k
Rv_15_19 n_15_19 n_16_19 1k
Rv_16_19 n_16_19 n_17_19 1k
Rv_17_19 n_17_19 n_18_19 1k
Rv_18_19 n_18_19 n_19_19 1k
Rv_19_19 n_19_19 n_20_19 1k
Rv_20_19 n_20_19 n_21_19 1k
Rv_21_19 n_21_19 n_22_19 1k
Rv_22_19 n_22_19 n_23_19 1k
Rv_23_19 n_23_19 n_24_19 1k
Rv_24_19 n_24_19 n_25_19 1k
Rv_25_19 n_25_19 n_26_19 1k
Rv_26_19 n_26_19 n_27_19 1k
Rv_27_19 n_27_19 n_28_19 1k
Rv_28_19 n_28_19 n_29_19 1k
Rv_29_19 n_29_19 n_30_19 1k
Rv_30_19 n_30_19 n_31_19 1k
Rv_31_19 n_31_19 n_32_19 1k
Rv_32_19 n_32_19 n_33_19 1k
Rv_33_19 n_33_19 n_34_19 1k
Rv_34_19 n_34_19 n_35_19 1k
Rv_35_19 n_35_19 n_36_19 1k
Rv_36_19 n_36_19 n_37_19 1k
Rv_37_19 n_37_19 n_38_19 1k

* Vertical resistors (Column 20)
Rv_0_20 n_0_20 n_1_20 1k
Rv_1_20 n_1_20 n_2_20 1k
Rv_2_20 n_2_20 n_3_20 1k
Rv_3_20 n_3_20 n_4_20 1k
Rv_4_20 n_4_20 n_5_20 1k
Rv_5_20 n_5_20 n_6_20 1k
Rv_6_20 n_6_20 n_7_20 1k
Rv_7_20 n_7_20 n_8_20 1k
Rv_8_20 n_8_20 n_9_20 1k
Rv_9_20 n_9_20 n_10_20 1k
Rv_10_20 n_10_20 n_11_20 1k
Rv_11_20 n_11_20 n_12_20 1k
Rv_12_20 n_12_20 n_13_20 1k
Rv_13_20 n_13_20 n_14_20 1k
Rv_14_20 n_14_20 n_15_20 1k
Rv_15_20 n_15_20 n_16_20 1k
Rv_16_20 n_16_20 n_17_20 1k
Rv_17_20 n_17_20 n_18_20 1k
Rv_18_20 n_18_20 n_19_20 1k
Rv_19_20 n_19_20 n_20_20 1k
Rv_20_20 n_20_20 n_21_20 1k
Rv_21_20 n_21_20 n_22_20 1k
Rv_22_20 n_22_20 n_23_20 1k
Rv_23_20 n_23_20 n_24_20 1k
Rv_24_20 n_24_20 n_25_20 1k
Rv_25_20 n_25_20 n_26_20 1k
Rv_26_20 n_26_20 n_27_20 1k
Rv_27_20 n_27_20 n_28_20 1k
Rv_28_20 n_28_20 n_29_20 1k
Rv_29_20 n_29_20 n_30_20 1k
Rv_30_20 n_30_20 n_31_20 1k
Rv_31_20 n_31_20 n_32_20 1k
Rv_32_20 n_32_20 n_33_20 1k
Rv_33_20 n_33_20 n_34_20 1k
Rv_34_20 n_34_20 n_35_20 1k
Rv_35_20 n_35_20 n_36_20 1k
Rv_36_20 n_36_20 n_37_20 1k
Rv_37_20 n_37_20 n_38_20 1k

* Vertical resistors (Column 21)
Rv_0_21 n_0_21 n_1_21 1k
Rv_1_21 n_1_21 n_2_21 1k
Rv_2_21 n_2_21 n_3_21 1k
Rv_3_21 n_3_21 n_4_21 1k
Rv_4_21 n_4_21 n_5_21 1k
Rv_5_21 n_5_21 n_6_21 1k
Rv_6_21 n_6_21 n_7_21 1k
Rv_7_21 n_7_21 n_8_21 1k
Rv_8_21 n_8_21 n_9_21 1k
Rv_9_21 n_9_21 n_10_21 1k
Rv_10_21 n_10_21 n_11_21 1k
Rv_11_21 n_11_21 n_12_21 1k
Rv_12_21 n_12_21 n_13_21 1k
Rv_13_21 n_13_21 n_14_21 1k
Rv_14_21 n_14_21 n_15_21 1k
Rv_15_21 n_15_21 n_16_21 1k
Rv_16_21 n_16_21 n_17_21 1k
Rv_17_21 n_17_21 n_18_21 1k
Rv_18_21 n_18_21 n_19_21 1k
Rv_19_21 n_19_21 n_20_21 1k
Rv_20_21 n_20_21 n_21_21 1k
Rv_21_21 n_21_21 n_22_21 1k
Rv_22_21 n_22_21 n_23_21 1k
Rv_23_21 n_23_21 n_24_21 1k
Rv_24_21 n_24_21 n_25_21 1k
Rv_25_21 n_25_21 n_26_21 1k
Rv_26_21 n_26_21 n_27_21 1k
Rv_27_21 n_27_21 n_28_21 1k
Rv_28_21 n_28_21 n_29_21 1k
Rv_29_21 n_29_21 n_30_21 1k
Rv_30_21 n_30_21 n_31_21 1k
Rv_31_21 n_31_21 n_32_21 1k
Rv_32_21 n_32_21 n_33_21 1k
Rv_33_21 n_33_21 n_34_21 1k
Rv_34_21 n_34_21 n_35_21 1k
Rv_35_21 n_35_21 n_36_21 1k
Rv_36_21 n_36_21 n_37_21 1k
Rv_37_21 n_37_21 n_38_21 1k

* Vertical resistors (Column 22)
Rv_0_22 n_0_22 n_1_22 1k
Rv_1_22 n_1_22 n_2_22 1k
Rv_2_22 n_2_22 n_3_22 1k
Rv_3_22 n_3_22 n_4_22 1k
Rv_4_22 n_4_22 n_5_22 1k
Rv_5_22 n_5_22 n_6_22 1k
Rv_6_22 n_6_22 n_7_22 1k
Rv_7_22 n_7_22 n_8_22 1k
Rv_8_22 n_8_22 n_9_22 1k
Rv_9_22 n_9_22 n_10_22 1k
Rv_10_22 n_10_22 n_11_22 1k
Rv_11_22 n_11_22 n_12_22 1k
Rv_12_22 n_12_22 n_13_22 1k
Rv_13_22 n_13_22 n_14_22 1k
Rv_14_22 n_14_22 n_15_22 1k
Rv_15_22 n_15_22 n_16_22 1k
Rv_16_22 n_16_22 n_17_22 1k
Rv_17_22 n_17_22 n_18_22 1k
Rv_18_22 n_18_22 n_19_22 1k
Rv_19_22 n_19_22 n_20_22 1k
Rv_20_22 n_20_22 n_21_22 1k
Rv_21_22 n_21_22 n_22_22 1k
Rv_22_22 n_22_22 n_23_22 1k
Rv_23_22 n_23_22 n_24_22 1k
Rv_24_22 n_24_22 n_25_22 1k
Rv_25_22 n_25_22 n_26_22 1k
Rv_26_22 n_26_22 n_27_22 1k
Rv_27_22 n_27_22 n_28_22 1k
Rv_28_22 n_28_22 n_29_22 1k
Rv_29_22 n_29_22 n_30_22 1k
Rv_30_22 n_30_22 n_31_22 1k
Rv_31_22 n_31_22 n_32_22 1k
Rv_32_22 n_32_22 n_33_22 1k
Rv_33_22 n_33_22 n_34_22 1k
Rv_34_22 n_34_22 n_35_22 1k
Rv_35_22 n_35_22 n_36_22 1k
Rv_36_22 n_36_22 n_37_22 1k
Rv_37_22 n_37_22 n_38_22 1k

* Vertical resistors (Column 23)
Rv_0_23 n_0_23 n_1_23 1k
Rv_1_23 n_1_23 n_2_23 1k
Rv_2_23 n_2_23 n_3_23 1k
Rv_3_23 n_3_23 n_4_23 1k
Rv_4_23 n_4_23 n_5_23 1k
Rv_5_23 n_5_23 n_6_23 1k
Rv_6_23 n_6_23 n_7_23 1k
Rv_7_23 n_7_23 n_8_23 1k
Rv_8_23 n_8_23 n_9_23 1k
Rv_9_23 n_9_23 n_10_23 1k
Rv_10_23 n_10_23 n_11_23 1k
Rv_11_23 n_11_23 n_12_23 1k
Rv_12_23 n_12_23 n_13_23 1k
Rv_13_23 n_13_23 n_14_23 1k
Rv_14_23 n_14_23 n_15_23 1k
Rv_15_23 n_15_23 n_16_23 1k
Rv_16_23 n_16_23 n_17_23 1k
Rv_17_23 n_17_23 n_18_23 1k
Rv_18_23 n_18_23 n_19_23 1k
Rv_19_23 n_19_23 n_20_23 1k
Rv_20_23 n_20_23 n_21_23 1k
Rv_21_23 n_21_23 n_22_23 1k
Rv_22_23 n_22_23 n_23_23 1k
Rv_23_23 n_23_23 n_24_23 1k
Rv_24_23 n_24_23 n_25_23 1k
Rv_25_23 n_25_23 n_26_23 1k
Rv_26_23 n_26_23 n_27_23 1k
Rv_27_23 n_27_23 n_28_23 1k
Rv_28_23 n_28_23 n_29_23 1k
Rv_29_23 n_29_23 n_30_23 1k
Rv_30_23 n_30_23 n_31_23 1k
Rv_31_23 n_31_23 n_32_23 1k
Rv_32_23 n_32_23 n_33_23 1k
Rv_33_23 n_33_23 n_34_23 1k
Rv_34_23 n_34_23 n_35_23 1k
Rv_35_23 n_35_23 n_36_23 1k
Rv_36_23 n_36_23 n_37_23 1k
Rv_37_23 n_37_23 n_38_23 1k

* Vertical resistors (Column 24)
Rv_0_24 n_0_24 n_1_24 1k
Rv_1_24 n_1_24 n_2_24 1k
Rv_2_24 n_2_24 n_3_24 1k
Rv_3_24 n_3_24 n_4_24 1k
Rv_4_24 n_4_24 n_5_24 1k
Rv_5_24 n_5_24 n_6_24 1k
Rv_6_24 n_6_24 n_7_24 1k
Rv_7_24 n_7_24 n_8_24 1k
Rv_8_24 n_8_24 n_9_24 1k
Rv_9_24 n_9_24 n_10_24 1k
Rv_10_24 n_10_24 n_11_24 1k
Rv_11_24 n_11_24 n_12_24 1k
Rv_12_24 n_12_24 n_13_24 1k
Rv_13_24 n_13_24 n_14_24 1k
Rv_14_24 n_14_24 n_15_24 1k
Rv_15_24 n_15_24 n_16_24 1k
Rv_16_24 n_16_24 n_17_24 1k
Rv_17_24 n_17_24 n_18_24 1k
Rv_18_24 n_18_24 n_19_24 1k
Rv_19_24 n_19_24 n_20_24 1k
Rv_20_24 n_20_24 n_21_24 1k
Rv_21_24 n_21_24 n_22_24 1k
Rv_22_24 n_22_24 n_23_24 1k
Rv_23_24 n_23_24 n_24_24 1k
Rv_24_24 n_24_24 n_25_24 1k
Rv_25_24 n_25_24 n_26_24 1k
Rv_26_24 n_26_24 n_27_24 1k
Rv_27_24 n_27_24 n_28_24 1k
Rv_28_24 n_28_24 n_29_24 1k
Rv_29_24 n_29_24 n_30_24 1k
Rv_30_24 n_30_24 n_31_24 1k
Rv_31_24 n_31_24 n_32_24 1k
Rv_32_24 n_32_24 n_33_24 1k
Rv_33_24 n_33_24 n_34_24 1k
Rv_34_24 n_34_24 n_35_24 1k
Rv_35_24 n_35_24 n_36_24 1k
Rv_36_24 n_36_24 n_37_24 1k
Rv_37_24 n_37_24 n_38_24 1k

* Vertical resistors (Column 25)
Rv_0_25 n_0_25 n_1_25 1k
Rv_1_25 n_1_25 n_2_25 1k
Rv_2_25 n_2_25 n_3_25 1k
Rv_3_25 n_3_25 n_4_25 1k
Rv_4_25 n_4_25 n_5_25 1k
Rv_5_25 n_5_25 n_6_25 1k
Rv_6_25 n_6_25 n_7_25 1k
Rv_7_25 n_7_25 n_8_25 1k
Rv_8_25 n_8_25 n_9_25 1k
Rv_9_25 n_9_25 n_10_25 1k
Rv_10_25 n_10_25 n_11_25 1k
Rv_11_25 n_11_25 n_12_25 1k
Rv_12_25 n_12_25 n_13_25 1k
Rv_13_25 n_13_25 n_14_25 1k
Rv_14_25 n_14_25 n_15_25 1k
Rv_15_25 n_15_25 n_16_25 1k
Rv_16_25 n_16_25 n_17_25 1k
Rv_17_25 n_17_25 n_18_25 1k
Rv_18_25 n_18_25 n_19_25 1k
Rv_19_25 n_19_25 n_20_25 1k
Rv_20_25 n_20_25 n_21_25 1k
Rv_21_25 n_21_25 n_22_25 1k
Rv_22_25 n_22_25 n_23_25 1k
Rv_23_25 n_23_25 n_24_25 1k
Rv_24_25 n_24_25 n_25_25 1k
Rv_25_25 n_25_25 n_26_25 1k
Rv_26_25 n_26_25 n_27_25 1k
Rv_27_25 n_27_25 n_28_25 1k
Rv_28_25 n_28_25 n_29_25 1k
Rv_29_25 n_29_25 n_30_25 1k
Rv_30_25 n_30_25 n_31_25 1k
Rv_31_25 n_31_25 n_32_25 1k
Rv_32_25 n_32_25 n_33_25 1k
Rv_33_25 n_33_25 n_34_25 1k
Rv_34_25 n_34_25 n_35_25 1k
Rv_35_25 n_35_25 n_36_25 1k
Rv_36_25 n_36_25 n_37_25 1k
Rv_37_25 n_37_25 n_38_25 1k

* Vertical resistors (Column 26)
Rv_0_26 n_0_26 n_1_26 1k
Rv_1_26 n_1_26 n_2_26 1k
Rv_2_26 n_2_26 n_3_26 1k
Rv_3_26 n_3_26 n_4_26 1k
Rv_4_26 n_4_26 n_5_26 1k
Rv_5_26 n_5_26 n_6_26 1k
Rv_6_26 n_6_26 n_7_26 1k
Rv_7_26 n_7_26 n_8_26 1k
Rv_8_26 n_8_26 n_9_26 1k
Rv_9_26 n_9_26 n_10_26 1k
Rv_10_26 n_10_26 n_11_26 1k
Rv_11_26 n_11_26 n_12_26 1k
Rv_12_26 n_12_26 n_13_26 1k
Rv_13_26 n_13_26 n_14_26 1k
Rv_14_26 n_14_26 n_15_26 1k
Rv_15_26 n_15_26 n_16_26 1k
Rv_16_26 n_16_26 n_17_26 1k
Rv_17_26 n_17_26 n_18_26 1k
Rv_18_26 n_18_26 n_19_26 1k
Rv_19_26 n_19_26 n_20_26 1k
Rv_20_26 n_20_26 n_21_26 1k
Rv_21_26 n_21_26 n_22_26 1k
Rv_22_26 n_22_26 n_23_26 1k
Rv_23_26 n_23_26 n_24_26 1k
Rv_24_26 n_24_26 n_25_26 1k
Rv_25_26 n_25_26 n_26_26 1k
Rv_26_26 n_26_26 n_27_26 1k
Rv_27_26 n_27_26 n_28_26 1k
Rv_28_26 n_28_26 n_29_26 1k
Rv_29_26 n_29_26 n_30_26 1k
Rv_30_26 n_30_26 n_31_26 1k
Rv_31_26 n_31_26 n_32_26 1k
Rv_32_26 n_32_26 n_33_26 1k
Rv_33_26 n_33_26 n_34_26 1k
Rv_34_26 n_34_26 n_35_26 1k
Rv_35_26 n_35_26 n_36_26 1k
Rv_36_26 n_36_26 n_37_26 1k
Rv_37_26 n_37_26 n_38_26 1k

* Vertical resistors (Column 27)
Rv_0_27 n_0_27 n_1_27 1k
Rv_1_27 n_1_27 n_2_27 1k
Rv_2_27 n_2_27 n_3_27 1k
Rv_3_27 n_3_27 n_4_27 1k
Rv_4_27 n_4_27 n_5_27 1k
Rv_5_27 n_5_27 n_6_27 1k
Rv_6_27 n_6_27 n_7_27 1k
Rv_7_27 n_7_27 n_8_27 1k
Rv_8_27 n_8_27 n_9_27 1k
Rv_9_27 n_9_27 n_10_27 1k
Rv_10_27 n_10_27 n_11_27 1k
Rv_11_27 n_11_27 n_12_27 1k
Rv_12_27 n_12_27 n_13_27 1k
Rv_13_27 n_13_27 n_14_27 1k
Rv_14_27 n_14_27 n_15_27 1k
Rv_15_27 n_15_27 n_16_27 1k
Rv_16_27 n_16_27 n_17_27 1k
Rv_17_27 n_17_27 n_18_27 1k
Rv_18_27 n_18_27 n_19_27 1k
Rv_19_27 n_19_27 n_20_27 1k
Rv_20_27 n_20_27 n_21_27 1k
Rv_21_27 n_21_27 n_22_27 1k
Rv_22_27 n_22_27 n_23_27 1k
Rv_23_27 n_23_27 n_24_27 1k
Rv_24_27 n_24_27 n_25_27 1k
Rv_25_27 n_25_27 n_26_27 1k
Rv_26_27 n_26_27 n_27_27 1k
Rv_27_27 n_27_27 n_28_27 1k
Rv_28_27 n_28_27 n_29_27 1k
Rv_29_27 n_29_27 n_30_27 1k
Rv_30_27 n_30_27 n_31_27 1k
Rv_31_27 n_31_27 n_32_27 1k
Rv_32_27 n_32_27 n_33_27 1k
Rv_33_27 n_33_27 n_34_27 1k
Rv_34_27 n_34_27 n_35_27 1k
Rv_35_27 n_35_27 n_36_27 1k
Rv_36_27 n_36_27 n_37_27 1k
Rv_37_27 n_37_27 n_38_27 1k

* Vertical resistors (Column 28)
Rv_0_28 n_0_28 n_1_28 1k
Rv_1_28 n_1_28 n_2_28 1k
Rv_2_28 n_2_28 n_3_28 1k
Rv_3_28 n_3_28 n_4_28 1k
Rv_4_28 n_4_28 n_5_28 1k
Rv_5_28 n_5_28 n_6_28 1k
Rv_6_28 n_6_28 n_7_28 1k
Rv_7_28 n_7_28 n_8_28 1k
Rv_8_28 n_8_28 n_9_28 1k
Rv_9_28 n_9_28 n_10_28 1k
Rv_10_28 n_10_28 n_11_28 1k
Rv_11_28 n_11_28 n_12_28 1k
Rv_12_28 n_12_28 n_13_28 1k
Rv_13_28 n_13_28 n_14_28 1k
Rv_14_28 n_14_28 n_15_28 1k
Rv_15_28 n_15_28 n_16_28 1k
Rv_16_28 n_16_28 n_17_28 1k
Rv_17_28 n_17_28 n_18_28 1k
Rv_18_28 n_18_28 n_19_28 1k
Rv_19_28 n_19_28 n_20_28 1k
Rv_20_28 n_20_28 n_21_28 1k
Rv_21_28 n_21_28 n_22_28 1k
Rv_22_28 n_22_28 n_23_28 1k
Rv_23_28 n_23_28 n_24_28 1k
Rv_24_28 n_24_28 n_25_28 1k
Rv_25_28 n_25_28 n_26_28 1k
Rv_26_28 n_26_28 n_27_28 1k
Rv_27_28 n_27_28 n_28_28 1k
Rv_28_28 n_28_28 n_29_28 1k
Rv_29_28 n_29_28 n_30_28 1k
Rv_30_28 n_30_28 n_31_28 1k
Rv_31_28 n_31_28 n_32_28 1k
Rv_32_28 n_32_28 n_33_28 1k
Rv_33_28 n_33_28 n_34_28 1k
Rv_34_28 n_34_28 n_35_28 1k
Rv_35_28 n_35_28 n_36_28 1k
Rv_36_28 n_36_28 n_37_28 1k
Rv_37_28 n_37_28 n_38_28 1k

* Vertical resistors (Column 29)
Rv_0_29 n_0_29 n_1_29 1k
Rv_1_29 n_1_29 n_2_29 1k
Rv_2_29 n_2_29 n_3_29 1k
Rv_3_29 n_3_29 n_4_29 1k
Rv_4_29 n_4_29 n_5_29 1k
Rv_5_29 n_5_29 n_6_29 1k
Rv_6_29 n_6_29 n_7_29 1k
Rv_7_29 n_7_29 n_8_29 1k
Rv_8_29 n_8_29 n_9_29 1k
Rv_9_29 n_9_29 n_10_29 1k
Rv_10_29 n_10_29 n_11_29 1k
Rv_11_29 n_11_29 n_12_29 1k
Rv_12_29 n_12_29 n_13_29 1k
Rv_13_29 n_13_29 n_14_29 1k
Rv_14_29 n_14_29 n_15_29 1k
Rv_15_29 n_15_29 n_16_29 1k
Rv_16_29 n_16_29 n_17_29 1k
Rv_17_29 n_17_29 n_18_29 1k
Rv_18_29 n_18_29 n_19_29 1k
Rv_19_29 n_19_29 n_20_29 1k
Rv_20_29 n_20_29 n_21_29 1k
Rv_21_29 n_21_29 n_22_29 1k
Rv_22_29 n_22_29 n_23_29 1k
Rv_23_29 n_23_29 n_24_29 1k
Rv_24_29 n_24_29 n_25_29 1k
Rv_25_29 n_25_29 n_26_29 1k
Rv_26_29 n_26_29 n_27_29 1k
Rv_27_29 n_27_29 n_28_29 1k
Rv_28_29 n_28_29 n_29_29 1k
Rv_29_29 n_29_29 n_30_29 1k
Rv_30_29 n_30_29 n_31_29 1k
Rv_31_29 n_31_29 n_32_29 1k
Rv_32_29 n_32_29 n_33_29 1k
Rv_33_29 n_33_29 n_34_29 1k
Rv_34_29 n_34_29 n_35_29 1k
Rv_35_29 n_35_29 n_36_29 1k
Rv_36_29 n_36_29 n_37_29 1k
Rv_37_29 n_37_29 n_38_29 1k

* Vertical resistors (Column 30)
Rv_0_30 n_0_30 n_1_30 1k
Rv_1_30 n_1_30 n_2_30 1k
Rv_2_30 n_2_30 n_3_30 1k
Rv_3_30 n_3_30 n_4_30 1k
Rv_4_30 n_4_30 n_5_30 1k
Rv_5_30 n_5_30 n_6_30 1k
Rv_6_30 n_6_30 n_7_30 1k
Rv_7_30 n_7_30 n_8_30 1k
Rv_8_30 n_8_30 n_9_30 1k
Rv_9_30 n_9_30 n_10_30 1k
Rv_10_30 n_10_30 n_11_30 1k
Rv_11_30 n_11_30 n_12_30 1k
Rv_12_30 n_12_30 n_13_30 1k
Rv_13_30 n_13_30 n_14_30 1k
Rv_14_30 n_14_30 n_15_30 1k
Rv_15_30 n_15_30 n_16_30 1k
Rv_16_30 n_16_30 n_17_30 1k
Rv_17_30 n_17_30 n_18_30 1k
Rv_18_30 n_18_30 n_19_30 1k
Rv_19_30 n_19_30 n_20_30 1k
Rv_20_30 n_20_30 n_21_30 1k
Rv_21_30 n_21_30 n_22_30 1k
Rv_22_30 n_22_30 n_23_30 1k
Rv_23_30 n_23_30 n_24_30 1k
Rv_24_30 n_24_30 n_25_30 1k
Rv_25_30 n_25_30 n_26_30 1k
Rv_26_30 n_26_30 n_27_30 1k
Rv_27_30 n_27_30 n_28_30 1k
Rv_28_30 n_28_30 n_29_30 1k
Rv_29_30 n_29_30 n_30_30 1k
Rv_30_30 n_30_30 n_31_30 1k
Rv_31_30 n_31_30 n_32_30 1k
Rv_32_30 n_32_30 n_33_30 1k
Rv_33_30 n_33_30 n_34_30 1k
Rv_34_30 n_34_30 n_35_30 1k
Rv_35_30 n_35_30 n_36_30 1k
Rv_36_30 n_36_30 n_37_30 1k
Rv_37_30 n_37_30 n_38_30 1k

* Vertical resistors (Column 31)
Rv_0_31 n_0_31 n_1_31 1k
Rv_1_31 n_1_31 n_2_31 1k
Rv_2_31 n_2_31 n_3_31 1k
Rv_3_31 n_3_31 n_4_31 1k
Rv_4_31 n_4_31 n_5_31 1k
Rv_5_31 n_5_31 n_6_31 1k
Rv_6_31 n_6_31 n_7_31 1k
Rv_7_31 n_7_31 n_8_31 1k
Rv_8_31 n_8_31 n_9_31 1k
Rv_9_31 n_9_31 n_10_31 1k
Rv_10_31 n_10_31 n_11_31 1k
Rv_11_31 n_11_31 n_12_31 1k
Rv_12_31 n_12_31 n_13_31 1k
Rv_13_31 n_13_31 n_14_31 1k
Rv_14_31 n_14_31 n_15_31 1k
Rv_15_31 n_15_31 n_16_31 1k
Rv_16_31 n_16_31 n_17_31 1k
Rv_17_31 n_17_31 n_18_31 1k
Rv_18_31 n_18_31 n_19_31 1k
Rv_19_31 n_19_31 n_20_31 1k
Rv_20_31 n_20_31 n_21_31 1k
Rv_21_31 n_21_31 n_22_31 1k
Rv_22_31 n_22_31 n_23_31 1k
Rv_23_31 n_23_31 n_24_31 1k
Rv_24_31 n_24_31 n_25_31 1k
Rv_25_31 n_25_31 n_26_31 1k
Rv_26_31 n_26_31 n_27_31 1k
Rv_27_31 n_27_31 n_28_31 1k
Rv_28_31 n_28_31 n_29_31 1k
Rv_29_31 n_29_31 n_30_31 1k
Rv_30_31 n_30_31 n_31_31 1k
Rv_31_31 n_31_31 n_32_31 1k
Rv_32_31 n_32_31 n_33_31 1k
Rv_33_31 n_33_31 n_34_31 1k
Rv_34_31 n_34_31 n_35_31 1k
Rv_35_31 n_35_31 n_36_31 1k
Rv_36_31 n_36_31 n_37_31 1k
Rv_37_31 n_37_31 n_38_31 1k

* Vertical resistors (Column 32)
Rv_0_32 n_0_32 n_1_32 1k
Rv_1_32 n_1_32 n_2_32 1k
Rv_2_32 n_2_32 n_3_32 1k
Rv_3_32 n_3_32 n_4_32 1k
Rv_4_32 n_4_32 n_5_32 1k
Rv_5_32 n_5_32 n_6_32 1k
Rv_6_32 n_6_32 n_7_32 1k
Rv_7_32 n_7_32 n_8_32 1k
Rv_8_32 n_8_32 n_9_32 1k
Rv_9_32 n_9_32 n_10_32 1k
Rv_10_32 n_10_32 n_11_32 1k
Rv_11_32 n_11_32 n_12_32 1k
Rv_12_32 n_12_32 n_13_32 1k
Rv_13_32 n_13_32 n_14_32 1k
Rv_14_32 n_14_32 n_15_32 1k
Rv_15_32 n_15_32 n_16_32 1k
Rv_16_32 n_16_32 n_17_32 1k
Rv_17_32 n_17_32 n_18_32 1k
Rv_18_32 n_18_32 n_19_32 1k
Rv_19_32 n_19_32 n_20_32 1k
Rv_20_32 n_20_32 n_21_32 1k
Rv_21_32 n_21_32 n_22_32 1k
Rv_22_32 n_22_32 n_23_32 1k
Rv_23_32 n_23_32 n_24_32 1k
Rv_24_32 n_24_32 n_25_32 1k
Rv_25_32 n_25_32 n_26_32 1k
Rv_26_32 n_26_32 n_27_32 1k
Rv_27_32 n_27_32 n_28_32 1k
Rv_28_32 n_28_32 n_29_32 1k
Rv_29_32 n_29_32 n_30_32 1k
Rv_30_32 n_30_32 n_31_32 1k
Rv_31_32 n_31_32 n_32_32 1k
Rv_32_32 n_32_32 n_33_32 1k
Rv_33_32 n_33_32 n_34_32 1k
Rv_34_32 n_34_32 n_35_32 1k
Rv_35_32 n_35_32 n_36_32 1k
Rv_36_32 n_36_32 n_37_32 1k
Rv_37_32 n_37_32 n_38_32 1k

* Vertical resistors (Column 33)
Rv_0_33 n_0_33 n_1_33 1k
Rv_1_33 n_1_33 n_2_33 1k
Rv_2_33 n_2_33 n_3_33 1k
Rv_3_33 n_3_33 n_4_33 1k
Rv_4_33 n_4_33 n_5_33 1k
Rv_5_33 n_5_33 n_6_33 1k
Rv_6_33 n_6_33 n_7_33 1k
Rv_7_33 n_7_33 n_8_33 1k
Rv_8_33 n_8_33 n_9_33 1k
Rv_9_33 n_9_33 n_10_33 1k
Rv_10_33 n_10_33 n_11_33 1k
Rv_11_33 n_11_33 n_12_33 1k
Rv_12_33 n_12_33 n_13_33 1k
Rv_13_33 n_13_33 n_14_33 1k
Rv_14_33 n_14_33 n_15_33 1k
Rv_15_33 n_15_33 n_16_33 1k
Rv_16_33 n_16_33 n_17_33 1k
Rv_17_33 n_17_33 n_18_33 1k
Rv_18_33 n_18_33 n_19_33 1k
Rv_19_33 n_19_33 n_20_33 1k
Rv_20_33 n_20_33 n_21_33 1k
Rv_21_33 n_21_33 n_22_33 1k
Rv_22_33 n_22_33 n_23_33 1k
Rv_23_33 n_23_33 n_24_33 1k
Rv_24_33 n_24_33 n_25_33 1k
Rv_25_33 n_25_33 n_26_33 1k
Rv_26_33 n_26_33 n_27_33 1k
Rv_27_33 n_27_33 n_28_33 1k
Rv_28_33 n_28_33 n_29_33 1k
Rv_29_33 n_29_33 n_30_33 1k
Rv_30_33 n_30_33 n_31_33 1k
Rv_31_33 n_31_33 n_32_33 1k
Rv_32_33 n_32_33 n_33_33 1k
Rv_33_33 n_33_33 n_34_33 1k
Rv_34_33 n_34_33 n_35_33 1k
Rv_35_33 n_35_33 n_36_33 1k
Rv_36_33 n_36_33 n_37_33 1k
Rv_37_33 n_37_33 n_38_33 1k

* Vertical resistors (Column 34)
Rv_0_34 n_0_34 n_1_34 1k
Rv_1_34 n_1_34 n_2_34 1k
Rv_2_34 n_2_34 n_3_34 1k
Rv_3_34 n_3_34 n_4_34 1k
Rv_4_34 n_4_34 n_5_34 1k
Rv_5_34 n_5_34 n_6_34 1k
Rv_6_34 n_6_34 n_7_34 1k
Rv_7_34 n_7_34 n_8_34 1k
Rv_8_34 n_8_34 n_9_34 1k
Rv_9_34 n_9_34 n_10_34 1k
Rv_10_34 n_10_34 n_11_34 1k
Rv_11_34 n_11_34 n_12_34 1k
Rv_12_34 n_12_34 n_13_34 1k
Rv_13_34 n_13_34 n_14_34 1k
Rv_14_34 n_14_34 n_15_34 1k
Rv_15_34 n_15_34 n_16_34 1k
Rv_16_34 n_16_34 n_17_34 1k
Rv_17_34 n_17_34 n_18_34 1k
Rv_18_34 n_18_34 n_19_34 1k
Rv_19_34 n_19_34 n_20_34 1k
Rv_20_34 n_20_34 n_21_34 1k
Rv_21_34 n_21_34 n_22_34 1k
Rv_22_34 n_22_34 n_23_34 1k
Rv_23_34 n_23_34 n_24_34 1k
Rv_24_34 n_24_34 n_25_34 1k
Rv_25_34 n_25_34 n_26_34 1k
Rv_26_34 n_26_34 n_27_34 1k
Rv_27_34 n_27_34 n_28_34 1k
Rv_28_34 n_28_34 n_29_34 1k
Rv_29_34 n_29_34 n_30_34 1k
Rv_30_34 n_30_34 n_31_34 1k
Rv_31_34 n_31_34 n_32_34 1k
Rv_32_34 n_32_34 n_33_34 1k
Rv_33_34 n_33_34 n_34_34 1k
Rv_34_34 n_34_34 n_35_34 1k
Rv_35_34 n_35_34 n_36_34 1k
Rv_36_34 n_36_34 n_37_34 1k
Rv_37_34 n_37_34 n_38_34 1k

* Vertical resistors (Column 35)
Rv_0_35 n_0_35 n_1_35 1k
Rv_1_35 n_1_35 n_2_35 1k
Rv_2_35 n_2_35 n_3_35 1k
Rv_3_35 n_3_35 n_4_35 1k
Rv_4_35 n_4_35 n_5_35 1k
Rv_5_35 n_5_35 n_6_35 1k
Rv_6_35 n_6_35 n_7_35 1k
Rv_7_35 n_7_35 n_8_35 1k
Rv_8_35 n_8_35 n_9_35 1k
Rv_9_35 n_9_35 n_10_35 1k
Rv_10_35 n_10_35 n_11_35 1k
Rv_11_35 n_11_35 n_12_35 1k
Rv_12_35 n_12_35 n_13_35 1k
Rv_13_35 n_13_35 n_14_35 1k
Rv_14_35 n_14_35 n_15_35 1k
Rv_15_35 n_15_35 n_16_35 1k
Rv_16_35 n_16_35 n_17_35 1k
Rv_17_35 n_17_35 n_18_35 1k
Rv_18_35 n_18_35 n_19_35 1k
Rv_19_35 n_19_35 n_20_35 1k
Rv_20_35 n_20_35 n_21_35 1k
Rv_21_35 n_21_35 n_22_35 1k
Rv_22_35 n_22_35 n_23_35 1k
Rv_23_35 n_23_35 n_24_35 1k
Rv_24_35 n_24_35 n_25_35 1k
Rv_25_35 n_25_35 n_26_35 1k
Rv_26_35 n_26_35 n_27_35 1k
Rv_27_35 n_27_35 n_28_35 1k
Rv_28_35 n_28_35 n_29_35 1k
Rv_29_35 n_29_35 n_30_35 1k
Rv_30_35 n_30_35 n_31_35 1k
Rv_31_35 n_31_35 n_32_35 1k
Rv_32_35 n_32_35 n_33_35 1k
Rv_33_35 n_33_35 n_34_35 1k
Rv_34_35 n_34_35 n_35_35 1k
Rv_35_35 n_35_35 n_36_35 1k
Rv_36_35 n_36_35 n_37_35 1k
Rv_37_35 n_37_35 n_38_35 1k

* Vertical resistors (Column 36)
Rv_0_36 n_0_36 n_1_36 1k
Rv_1_36 n_1_36 n_2_36 1k
Rv_2_36 n_2_36 n_3_36 1k
Rv_3_36 n_3_36 n_4_36 1k
Rv_4_36 n_4_36 n_5_36 1k
Rv_5_36 n_5_36 n_6_36 1k
Rv_6_36 n_6_36 n_7_36 1k
Rv_7_36 n_7_36 n_8_36 1k
Rv_8_36 n_8_36 n_9_36 1k
Rv_9_36 n_9_36 n_10_36 1k
Rv_10_36 n_10_36 n_11_36 1k
Rv_11_36 n_11_36 n_12_36 1k
Rv_12_36 n_12_36 n_13_36 1k
Rv_13_36 n_13_36 n_14_36 1k
Rv_14_36 n_14_36 n_15_36 1k
Rv_15_36 n_15_36 n_16_36 1k
Rv_16_36 n_16_36 n_17_36 1k
Rv_17_36 n_17_36 n_18_36 1k
Rv_18_36 n_18_36 n_19_36 1k
Rv_19_36 n_19_36 n_20_36 1k
Rv_20_36 n_20_36 n_21_36 1k
Rv_21_36 n_21_36 n_22_36 1k
Rv_22_36 n_22_36 n_23_36 1k
Rv_23_36 n_23_36 n_24_36 1k
Rv_24_36 n_24_36 n_25_36 1k
Rv_25_36 n_25_36 n_26_36 1k
Rv_26_36 n_26_36 n_27_36 1k
Rv_27_36 n_27_36 n_28_36 1k
Rv_28_36 n_28_36 n_29_36 1k
Rv_29_36 n_29_36 n_30_36 1k
Rv_30_36 n_30_36 n_31_36 1k
Rv_31_36 n_31_36 n_32_36 1k
Rv_32_36 n_32_36 n_33_36 1k
Rv_33_36 n_33_36 n_34_36 1k
Rv_34_36 n_34_36 n_35_36 1k
Rv_35_36 n_35_36 n_36_36 1k
Rv_36_36 n_36_36 n_37_36 1k
Rv_37_36 n_37_36 n_38_36 1k

* Vertical resistors (Column 37)
Rv_0_37 n_0_37 n_1_37 1k
Rv_1_37 n_1_37 n_2_37 1k
Rv_2_37 n_2_37 n_3_37 1k
Rv_3_37 n_3_37 n_4_37 1k
Rv_4_37 n_4_37 n_5_37 1k
Rv_5_37 n_5_37 n_6_37 1k
Rv_6_37 n_6_37 n_7_37 1k
Rv_7_37 n_7_37 n_8_37 1k
Rv_8_37 n_8_37 n_9_37 1k
Rv_9_37 n_9_37 n_10_37 1k
Rv_10_37 n_10_37 n_11_37 1k
Rv_11_37 n_11_37 n_12_37 1k
Rv_12_37 n_12_37 n_13_37 1k
Rv_13_37 n_13_37 n_14_37 1k
Rv_14_37 n_14_37 n_15_37 1k
Rv_15_37 n_15_37 n_16_37 1k
Rv_16_37 n_16_37 n_17_37 1k
Rv_17_37 n_17_37 n_18_37 1k
Rv_18_37 n_18_37 n_19_37 1k
Rv_19_37 n_19_37 n_20_37 1k
Rv_20_37 n_20_37 n_21_37 1k
Rv_21_37 n_21_37 n_22_37 1k
Rv_22_37 n_22_37 n_23_37 1k
Rv_23_37 n_23_37 n_24_37 1k
Rv_24_37 n_24_37 n_25_37 1k
Rv_25_37 n_25_37 n_26_37 1k
Rv_26_37 n_26_37 n_27_37 1k
Rv_27_37 n_27_37 n_28_37 1k
Rv_28_37 n_28_37 n_29_37 1k
Rv_29_37 n_29_37 n_30_37 1k
Rv_30_37 n_30_37 n_31_37 1k
Rv_31_37 n_31_37 n_32_37 1k
Rv_32_37 n_32_37 n_33_37 1k
Rv_33_37 n_33_37 n_34_37 1k
Rv_34_37 n_34_37 n_35_37 1k
Rv_35_37 n_35_37 n_36_37 1k
Rv_36_37 n_36_37 n_37_37 1k
Rv_37_37 n_37_37 n_38_37 1k

* Vertical resistors (Column 38)
Rv_0_38 n_0_38 n_1_38 1k
Rv_1_38 n_1_38 n_2_38 1k
Rv_2_38 n_2_38 n_3_38 1k
Rv_3_38 n_3_38 n_4_38 1k
Rv_4_38 n_4_38 n_5_38 1k
Rv_5_38 n_5_38 n_6_38 1k
Rv_6_38 n_6_38 n_7_38 1k
Rv_7_38 n_7_38 n_8_38 1k
Rv_8_38 n_8_38 n_9_38 1k
Rv_9_38 n_9_38 n_10_38 1k
Rv_10_38 n_10_38 n_11_38 1k
Rv_11_38 n_11_38 n_12_38 1k
Rv_12_38 n_12_38 n_13_38 1k
Rv_13_38 n_13_38 n_14_38 1k
Rv_14_38 n_14_38 n_15_38 1k
Rv_15_38 n_15_38 n_16_38 1k
Rv_16_38 n_16_38 n_17_38 1k
Rv_17_38 n_17_38 n_18_38 1k
Rv_18_38 n_18_38 n_19_38 1k
Rv_19_38 n_19_38 n_20_38 1k
Rv_20_38 n_20_38 n_21_38 1k
Rv_21_38 n_21_38 n_22_38 1k
Rv_22_38 n_22_38 n_23_38 1k
Rv_23_38 n_23_38 n_24_38 1k
Rv_24_38 n_24_38 n_25_38 1k
Rv_25_38 n_25_38 n_26_38 1k
Rv_26_38 n_26_38 n_27_38 1k
Rv_27_38 n_27_38 n_28_38 1k
Rv_28_38 n_28_38 n_29_38 1k
Rv_29_38 n_29_38 n_30_38 1k
Rv_30_38 n_30_38 n_31_38 1k
Rv_31_38 n_31_38 n_32_38 1k
Rv_32_38 n_32_38 n_33_38 1k
Rv_33_38 n_33_38 n_34_38 1k
Rv_34_38 n_34_38 n_35_38 1k
Rv_35_38 n_35_38 n_36_38 1k
Rv_36_38 n_36_38 n_37_38 1k
Rv_37_38 n_37_38 n_38_38 1k

* Load resistor at bottom-right corner
Rload n_38_38 0 1k

.op
.control
op
print all > resistor_mesh_39x39_dc_raw.txt
.endc
.end
