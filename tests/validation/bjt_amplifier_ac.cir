* BJT Common-Emitter Amplifier AC Analysis for validation
* Circuit: Vin(AC) -> Cin -> BJT(CE) -> Cout -> Rload

.model Q2N2222 NPN BF=100 IS=1e-14

* Power supply
Vcc vcc 0 DC 12

* Input signal (AC only)
Vin in 0 DC 0 AC 1

* Input coupling capacitor
Cin in base 10u

* Bias network
R1 vcc base 47k
R2 base 0 10k

* Emitter resistor with bypass capacitor
Re emitter 0 1k
Ce emitter 0 100u

* Collector resistor
Rc vcc collector 4.7k

* Output coupling capacitor
Cout collector out 10u

* Load resistor
Rload out 0 10k

* BJT
Q1 collector base emitter Q2N2222

.ac dec 20 10 100k

.control
ac dec 20 10 100k
wrdata bjt_amplifier_ac_ngspice.dat v(out)
.endc
.end
