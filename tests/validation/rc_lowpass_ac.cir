* RC Low-Pass Filter AC Analysis for validation
* Circuit: V(1V AC) -> R(1k) -> C(1u) -> GND
* Cutoff frequency: fc = 1/(2*pi*R*C) = 159.15 Hz

V1 in 0 DC 0 AC 1
R1 in out 1k
C1 out 0 1u

.ac dec 20 10 10k
.control
run
wrdata rc_lowpass_ac_ngspice.csv v(out)
.endc
.end
