* 22x22 Resistor Mesh DC Analysis for validation
* Circuit: Vin at n_0_0, GND via Rload at n_21_21
* Total devices: ~925 resistors

Vin n_0_0 0 DC 1

* Row 0
Rh_0_0 n_0_0 n_0_1 1k
Rh_0_1 n_0_1 n_0_2 1k
Rh_0_2 n_0_2 n_0_3 1k
Rh_0_3 n_0_3 n_0_4 1k
Rh_0_4 n_0_4 n_0_5 1k
Rh_0_5 n_0_5 n_0_6 1k
Rh_0_6 n_0_6 n_0_7 1k
Rh_0_7 n_0_7 n_0_8 1k
Rh_0_8 n_0_8 n_0_9 1k
Rh_0_9 n_0_9 n_0_10 1k
Rh_0_10 n_0_10 n_0_11 1k
Rh_0_11 n_0_11 n_0_12 1k
Rh_0_12 n_0_12 n_0_13 1k
Rh_0_13 n_0_13 n_0_14 1k
Rh_0_14 n_0_14 n_0_15 1k
Rh_0_15 n_0_15 n_0_16 1k
Rh_0_16 n_0_16 n_0_17 1k
Rh_0_17 n_0_17 n_0_18 1k
Rh_0_18 n_0_18 n_0_19 1k
Rh_0_19 n_0_19 n_0_20 1k
Rh_0_20 n_0_20 n_0_21 1k

* Row 1
Rh_1_0 n_1_0 n_1_1 1k
Rh_1_1 n_1_1 n_1_2 1k
Rh_1_2 n_1_2 n_1_3 1k
Rh_1_3 n_1_3 n_1_4 1k
Rh_1_4 n_1_4 n_1_5 1k
Rh_1_5 n_1_5 n_1_6 1k
Rh_1_6 n_1_6 n_1_7 1k
Rh_1_7 n_1_7 n_1_8 1k
Rh_1_8 n_1_8 n_1_9 1k
Rh_1_9 n_1_9 n_1_10 1k
Rh_1_10 n_1_10 n_1_11 1k
Rh_1_11 n_1_11 n_1_12 1k
Rh_1_12 n_1_12 n_1_13 1k
Rh_1_13 n_1_13 n_1_14 1k
Rh_1_14 n_1_14 n_1_15 1k
Rh_1_15 n_1_15 n_1_16 1k
Rh_1_16 n_1_16 n_1_17 1k
Rh_1_17 n_1_17 n_1_18 1k
Rh_1_18 n_1_18 n_1_19 1k
Rh_1_19 n_1_19 n_1_20 1k
Rh_1_20 n_1_20 n_1_21 1k

* Row 2
Rh_2_0 n_2_0 n_2_1 1k
Rh_2_1 n_2_1 n_2_2 1k
Rh_2_2 n_2_2 n_2_3 1k
Rh_2_3 n_2_3 n_2_4 1k
Rh_2_4 n_2_4 n_2_5 1k
Rh_2_5 n_2_5 n_2_6 1k
Rh_2_6 n_2_6 n_2_7 1k
Rh_2_7 n_2_7 n_2_8 1k
Rh_2_8 n_2_8 n_2_9 1k
Rh_2_9 n_2_9 n_2_10 1k
Rh_2_10 n_2_10 n_2_11 1k
Rh_2_11 n_2_11 n_2_12 1k
Rh_2_12 n_2_12 n_2_13 1k
Rh_2_13 n_2_13 n_2_14 1k
Rh_2_14 n_2_14 n_2_15 1k
Rh_2_15 n_2_15 n_2_16 1k
Rh_2_16 n_2_16 n_2_17 1k
Rh_2_17 n_2_17 n_2_18 1k
Rh_2_18 n_2_18 n_2_19 1k
Rh_2_19 n_2_19 n_2_20 1k
Rh_2_20 n_2_20 n_2_21 1k

* Row 3
Rh_3_0 n_3_0 n_3_1 1k
Rh_3_1 n_3_1 n_3_2 1k
Rh_3_2 n_3_2 n_3_3 1k
Rh_3_3 n_3_3 n_3_4 1k
Rh_3_4 n_3_4 n_3_5 1k
Rh_3_5 n_3_5 n_3_6 1k
Rh_3_6 n_3_6 n_3_7 1k
Rh_3_7 n_3_7 n_3_8 1k
Rh_3_8 n_3_8 n_3_9 1k
Rh_3_9 n_3_9 n_3_10 1k
Rh_3_10 n_3_10 n_3_11 1k
Rh_3_11 n_3_11 n_3_12 1k
Rh_3_12 n_3_12 n_3_13 1k
Rh_3_13 n_3_13 n_3_14 1k
Rh_3_14 n_3_14 n_3_15 1k
Rh_3_15 n_3_15 n_3_16 1k
Rh_3_16 n_3_16 n_3_17 1k
Rh_3_17 n_3_17 n_3_18 1k
Rh_3_18 n_3_18 n_3_19 1k
Rh_3_19 n_3_19 n_3_20 1k
Rh_3_20 n_3_20 n_3_21 1k

* Row 4
Rh_4_0 n_4_0 n_4_1 1k
Rh_4_1 n_4_1 n_4_2 1k
Rh_4_2 n_4_2 n_4_3 1k
Rh_4_3 n_4_3 n_4_4 1k
Rh_4_4 n_4_4 n_4_5 1k
Rh_4_5 n_4_5 n_4_6 1k
Rh_4_6 n_4_6 n_4_7 1k
Rh_4_7 n_4_7 n_4_8 1k
Rh_4_8 n_4_8 n_4_9 1k
Rh_4_9 n_4_9 n_4_10 1k
Rh_4_10 n_4_10 n_4_11 1k
Rh_4_11 n_4_11 n_4_12 1k
Rh_4_12 n_4_12 n_4_13 1k
Rh_4_13 n_4_13 n_4_14 1k
Rh_4_14 n_4_14 n_4_15 1k
Rh_4_15 n_4_15 n_4_16 1k
Rh_4_16 n_4_16 n_4_17 1k
Rh_4_17 n_4_17 n_4_18 1k
Rh_4_18 n_4_18 n_4_19 1k
Rh_4_19 n_4_19 n_4_20 1k
Rh_4_20 n_4_20 n_4_21 1k

* Row 5
Rh_5_0 n_5_0 n_5_1 1k
Rh_5_1 n_5_1 n_5_2 1k
Rh_5_2 n_5_2 n_5_3 1k
Rh_5_3 n_5_3 n_5_4 1k
Rh_5_4 n_5_4 n_5_5 1k
Rh_5_5 n_5_5 n_5_6 1k
Rh_5_6 n_5_6 n_5_7 1k
Rh_5_7 n_5_7 n_5_8 1k
Rh_5_8 n_5_8 n_5_9 1k
Rh_5_9 n_5_9 n_5_10 1k
Rh_5_10 n_5_10 n_5_11 1k
Rh_5_11 n_5_11 n_5_12 1k
Rh_5_12 n_5_12 n_5_13 1k
Rh_5_13 n_5_13 n_5_14 1k
Rh_5_14 n_5_14 n_5_15 1k
Rh_5_15 n_5_15 n_5_16 1k
Rh_5_16 n_5_16 n_5_17 1k
Rh_5_17 n_5_17 n_5_18 1k
Rh_5_18 n_5_18 n_5_19 1k
Rh_5_19 n_5_19 n_5_20 1k
Rh_5_20 n_5_20 n_5_21 1k

* Row 6
Rh_6_0 n_6_0 n_6_1 1k
Rh_6_1 n_6_1 n_6_2 1k
Rh_6_2 n_6_2 n_6_3 1k
Rh_6_3 n_6_3 n_6_4 1k
Rh_6_4 n_6_4 n_6_5 1k
Rh_6_5 n_6_5 n_6_6 1k
Rh_6_6 n_6_6 n_6_7 1k
Rh_6_7 n_6_7 n_6_8 1k
Rh_6_8 n_6_8 n_6_9 1k
Rh_6_9 n_6_9 n_6_10 1k
Rh_6_10 n_6_10 n_6_11 1k
Rh_6_11 n_6_11 n_6_12 1k
Rh_6_12 n_6_12 n_6_13 1k
Rh_6_13 n_6_13 n_6_14 1k
Rh_6_14 n_6_14 n_6_15 1k
Rh_6_15 n_6_15 n_6_16 1k
Rh_6_16 n_6_16 n_6_17 1k
Rh_6_17 n_6_17 n_6_18 1k
Rh_6_18 n_6_18 n_6_19 1k
Rh_6_19 n_6_19 n_6_20 1k
Rh_6_20 n_6_20 n_6_21 1k

* Row 7
Rh_7_0 n_7_0 n_7_1 1k
Rh_7_1 n_7_1 n_7_2 1k
Rh_7_2 n_7_2 n_7_3 1k
Rh_7_3 n_7_3 n_7_4 1k
Rh_7_4 n_7_4 n_7_5 1k
Rh_7_5 n_7_5 n_7_6 1k
Rh_7_6 n_7_6 n_7_7 1k
Rh_7_7 n_7_7 n_7_8 1k
Rh_7_8 n_7_8 n_7_9 1k
Rh_7_9 n_7_9 n_7_10 1k
Rh_7_10 n_7_10 n_7_11 1k
Rh_7_11 n_7_11 n_7_12 1k
Rh_7_12 n_7_12 n_7_13 1k
Rh_7_13 n_7_13 n_7_14 1k
Rh_7_14 n_7_14 n_7_15 1k
Rh_7_15 n_7_15 n_7_16 1k
Rh_7_16 n_7_16 n_7_17 1k
Rh_7_17 n_7_17 n_7_18 1k
Rh_7_18 n_7_18 n_7_19 1k
Rh_7_19 n_7_19 n_7_20 1k
Rh_7_20 n_7_20 n_7_21 1k

* Row 8
Rh_8_0 n_8_0 n_8_1 1k
Rh_8_1 n_8_1 n_8_2 1k
Rh_8_2 n_8_2 n_8_3 1k
Rh_8_3 n_8_3 n_8_4 1k
Rh_8_4 n_8_4 n_8_5 1k
Rh_8_5 n_8_5 n_8_6 1k
Rh_8_6 n_8_6 n_8_7 1k
Rh_8_7 n_8_7 n_8_8 1k
Rh_8_8 n_8_8 n_8_9 1k
Rh_8_9 n_8_9 n_8_10 1k
Rh_8_10 n_8_10 n_8_11 1k
Rh_8_11 n_8_11 n_8_12 1k
Rh_8_12 n_8_12 n_8_13 1k
Rh_8_13 n_8_13 n_8_14 1k
Rh_8_14 n_8_14 n_8_15 1k
Rh_8_15 n_8_15 n_8_16 1k
Rh_8_16 n_8_16 n_8_17 1k
Rh_8_17 n_8_17 n_8_18 1k
Rh_8_18 n_8_18 n_8_19 1k
Rh_8_19 n_8_19 n_8_20 1k
Rh_8_20 n_8_20 n_8_21 1k

* Row 9
Rh_9_0 n_9_0 n_9_1 1k
Rh_9_1 n_9_1 n_9_2 1k
Rh_9_2 n_9_2 n_9_3 1k
Rh_9_3 n_9_3 n_9_4 1k
Rh_9_4 n_9_4 n_9_5 1k
Rh_9_5 n_9_5 n_9_6 1k
Rh_9_6 n_9_6 n_9_7 1k
Rh_9_7 n_9_7 n_9_8 1k
Rh_9_8 n_9_8 n_9_9 1k
Rh_9_9 n_9_9 n_9_10 1k
Rh_9_10 n_9_10 n_9_11 1k
Rh_9_11 n_9_11 n_9_12 1k
Rh_9_12 n_9_12 n_9_13 1k
Rh_9_13 n_9_13 n_9_14 1k
Rh_9_14 n_9_14 n_9_15 1k
Rh_9_15 n_9_15 n_9_16 1k
Rh_9_16 n_9_16 n_9_17 1k
Rh_9_17 n_9_17 n_9_18 1k
Rh_9_18 n_9_18 n_9_19 1k
Rh_9_19 n_9_19 n_9_20 1k
Rh_9_20 n_9_20 n_9_21 1k

* Row 10
Rh_10_0 n_10_0 n_10_1 1k
Rh_10_1 n_10_1 n_10_2 1k
Rh_10_2 n_10_2 n_10_3 1k
Rh_10_3 n_10_3 n_10_4 1k
Rh_10_4 n_10_4 n_10_5 1k
Rh_10_5 n_10_5 n_10_6 1k
Rh_10_6 n_10_6 n_10_7 1k
Rh_10_7 n_10_7 n_10_8 1k
Rh_10_8 n_10_8 n_10_9 1k
Rh_10_9 n_10_9 n_10_10 1k
Rh_10_10 n_10_10 n_10_11 1k
Rh_10_11 n_10_11 n_10_12 1k
Rh_10_12 n_10_12 n_10_13 1k
Rh_10_13 n_10_13 n_10_14 1k
Rh_10_14 n_10_14 n_10_15 1k
Rh_10_15 n_10_15 n_10_16 1k
Rh_10_16 n_10_16 n_10_17 1k
Rh_10_17 n_10_17 n_10_18 1k
Rh_10_18 n_10_18 n_10_19 1k
Rh_10_19 n_10_19 n_10_20 1k
Rh_10_20 n_10_20 n_10_21 1k

* Row 11
Rh_11_0 n_11_0 n_11_1 1k
Rh_11_1 n_11_1 n_11_2 1k
Rh_11_2 n_11_2 n_11_3 1k
Rh_11_3 n_11_3 n_11_4 1k
Rh_11_4 n_11_4 n_11_5 1k
Rh_11_5 n_11_5 n_11_6 1k
Rh_11_6 n_11_6 n_11_7 1k
Rh_11_7 n_11_7 n_11_8 1k
Rh_11_8 n_11_8 n_11_9 1k
Rh_11_9 n_11_9 n_11_10 1k
Rh_11_10 n_11_10 n_11_11 1k
Rh_11_11 n_11_11 n_11_12 1k
Rh_11_12 n_11_12 n_11_13 1k
Rh_11_13 n_11_13 n_11_14 1k
Rh_11_14 n_11_14 n_11_15 1k
Rh_11_15 n_11_15 n_11_16 1k
Rh_11_16 n_11_16 n_11_17 1k
Rh_11_17 n_11_17 n_11_18 1k
Rh_11_18 n_11_18 n_11_19 1k
Rh_11_19 n_11_19 n_11_20 1k
Rh_11_20 n_11_20 n_11_21 1k

* Row 12
Rh_12_0 n_12_0 n_12_1 1k
Rh_12_1 n_12_1 n_12_2 1k
Rh_12_2 n_12_2 n_12_3 1k
Rh_12_3 n_12_3 n_12_4 1k
Rh_12_4 n_12_4 n_12_5 1k
Rh_12_5 n_12_5 n_12_6 1k
Rh_12_6 n_12_6 n_12_7 1k
Rh_12_7 n_12_7 n_12_8 1k
Rh_12_8 n_12_8 n_12_9 1k
Rh_12_9 n_12_9 n_12_10 1k
Rh_12_10 n_12_10 n_12_11 1k
Rh_12_11 n_12_11 n_12_12 1k
Rh_12_12 n_12_12 n_12_13 1k
Rh_12_13 n_12_13 n_12_14 1k
Rh_12_14 n_12_14 n_12_15 1k
Rh_12_15 n_12_15 n_12_16 1k
Rh_12_16 n_12_16 n_12_17 1k
Rh_12_17 n_12_17 n_12_18 1k
Rh_12_18 n_12_18 n_12_19 1k
Rh_12_19 n_12_19 n_12_20 1k
Rh_12_20 n_12_20 n_12_21 1k

* Row 13
Rh_13_0 n_13_0 n_13_1 1k
Rh_13_1 n_13_1 n_13_2 1k
Rh_13_2 n_13_2 n_13_3 1k
Rh_13_3 n_13_3 n_13_4 1k
Rh_13_4 n_13_4 n_13_5 1k
Rh_13_5 n_13_5 n_13_6 1k
Rh_13_6 n_13_6 n_13_7 1k
Rh_13_7 n_13_7 n_13_8 1k
Rh_13_8 n_13_8 n_13_9 1k
Rh_13_9 n_13_9 n_13_10 1k
Rh_13_10 n_13_10 n_13_11 1k
Rh_13_11 n_13_11 n_13_12 1k
Rh_13_12 n_13_12 n_13_13 1k
Rh_13_13 n_13_13 n_13_14 1k
Rh_13_14 n_13_14 n_13_15 1k
Rh_13_15 n_13_15 n_13_16 1k
Rh_13_16 n_13_16 n_13_17 1k
Rh_13_17 n_13_17 n_13_18 1k
Rh_13_18 n_13_18 n_13_19 1k
Rh_13_19 n_13_19 n_13_20 1k
Rh_13_20 n_13_20 n_13_21 1k

* Row 14
Rh_14_0 n_14_0 n_14_1 1k
Rh_14_1 n_14_1 n_14_2 1k
Rh_14_2 n_14_2 n_14_3 1k
Rh_14_3 n_14_3 n_14_4 1k
Rh_14_4 n_14_4 n_14_5 1k
Rh_14_5 n_14_5 n_14_6 1k
Rh_14_6 n_14_6 n_14_7 1k
Rh_14_7 n_14_7 n_14_8 1k
Rh_14_8 n_14_8 n_14_9 1k
Rh_14_9 n_14_9 n_14_10 1k
Rh_14_10 n_14_10 n_14_11 1k
Rh_14_11 n_14_11 n_14_12 1k
Rh_14_12 n_14_12 n_14_13 1k
Rh_14_13 n_14_13 n_14_14 1k
Rh_14_14 n_14_14 n_14_15 1k
Rh_14_15 n_14_15 n_14_16 1k
Rh_14_16 n_14_16 n_14_17 1k
Rh_14_17 n_14_17 n_14_18 1k
Rh_14_18 n_14_18 n_14_19 1k
Rh_14_19 n_14_19 n_14_20 1k
Rh_14_20 n_14_20 n_14_21 1k

* Row 15
Rh_15_0 n_15_0 n_15_1 1k
Rh_15_1 n_15_1 n_15_2 1k
Rh_15_2 n_15_2 n_15_3 1k
Rh_15_3 n_15_3 n_15_4 1k
Rh_15_4 n_15_4 n_15_5 1k
Rh_15_5 n_15_5 n_15_6 1k
Rh_15_6 n_15_6 n_15_7 1k
Rh_15_7 n_15_7 n_15_8 1k
Rh_15_8 n_15_8 n_15_9 1k
Rh_15_9 n_15_9 n_15_10 1k
Rh_15_10 n_15_10 n_15_11 1k
Rh_15_11 n_15_11 n_15_12 1k
Rh_15_12 n_15_12 n_15_13 1k
Rh_15_13 n_15_13 n_15_14 1k
Rh_15_14 n_15_14 n_15_15 1k
Rh_15_15 n_15_15 n_15_16 1k
Rh_15_16 n_15_16 n_15_17 1k
Rh_15_17 n_15_17 n_15_18 1k
Rh_15_18 n_15_18 n_15_19 1k
Rh_15_19 n_15_19 n_15_20 1k
Rh_15_20 n_15_20 n_15_21 1k

* Row 16
Rh_16_0 n_16_0 n_16_1 1k
Rh_16_1 n_16_1 n_16_2 1k
Rh_16_2 n_16_2 n_16_3 1k
Rh_16_3 n_16_3 n_16_4 1k
Rh_16_4 n_16_4 n_16_5 1k
Rh_16_5 n_16_5 n_16_6 1k
Rh_16_6 n_16_6 n_16_7 1k
Rh_16_7 n_16_7 n_16_8 1k
Rh_16_8 n_16_8 n_16_9 1k
Rh_16_9 n_16_9 n_16_10 1k
Rh_16_10 n_16_10 n_16_11 1k
Rh_16_11 n_16_11 n_16_12 1k
Rh_16_12 n_16_12 n_16_13 1k
Rh_16_13 n_16_13 n_16_14 1k
Rh_16_14 n_16_14 n_16_15 1k
Rh_16_15 n_16_15 n_16_16 1k
Rh_16_16 n_16_16 n_16_17 1k
Rh_16_17 n_16_17 n_16_18 1k
Rh_16_18 n_16_18 n_16_19 1k
Rh_16_19 n_16_19 n_16_20 1k
Rh_16_20 n_16_20 n_16_21 1k

* Row 17
Rh_17_0 n_17_0 n_17_1 1k
Rh_17_1 n_17_1 n_17_2 1k
Rh_17_2 n_17_2 n_17_3 1k
Rh_17_3 n_17_3 n_17_4 1k
Rh_17_4 n_17_4 n_17_5 1k
Rh_17_5 n_17_5 n_17_6 1k
Rh_17_6 n_17_6 n_17_7 1k
Rh_17_7 n_17_7 n_17_8 1k
Rh_17_8 n_17_8 n_17_9 1k
Rh_17_9 n_17_9 n_17_10 1k
Rh_17_10 n_17_10 n_17_11 1k
Rh_17_11 n_17_11 n_17_12 1k
Rh_17_12 n_17_12 n_17_13 1k
Rh_17_13 n_17_13 n_17_14 1k
Rh_17_14 n_17_14 n_17_15 1k
Rh_17_15 n_17_15 n_17_16 1k
Rh_17_16 n_17_16 n_17_17 1k
Rh_17_17 n_17_17 n_17_18 1k
Rh_17_18 n_17_18 n_17_19 1k
Rh_17_19 n_17_19 n_17_20 1k
Rh_17_20 n_17_20 n_17_21 1k

* Row 18
Rh_18_0 n_18_0 n_18_1 1k
Rh_18_1 n_18_1 n_18_2 1k
Rh_18_2 n_18_2 n_18_3 1k
Rh_18_3 n_18_3 n_18_4 1k
Rh_18_4 n_18_4 n_18_5 1k
Rh_18_5 n_18_5 n_18_6 1k
Rh_18_6 n_18_6 n_18_7 1k
Rh_18_7 n_18_7 n_18_8 1k
Rh_18_8 n_18_8 n_18_9 1k
Rh_18_9 n_18_9 n_18_10 1k
Rh_18_10 n_18_10 n_18_11 1k
Rh_18_11 n_18_11 n_18_12 1k
Rh_18_12 n_18_12 n_18_13 1k
Rh_18_13 n_18_13 n_18_14 1k
Rh_18_14 n_18_14 n_18_15 1k
Rh_18_15 n_18_15 n_18_16 1k
Rh_18_16 n_18_16 n_18_17 1k
Rh_18_17 n_18_17 n_18_18 1k
Rh_18_18 n_18_18 n_18_19 1k
Rh_18_19 n_18_19 n_18_20 1k
Rh_18_20 n_18_20 n_18_21 1k

* Row 19
Rh_19_0 n_19_0 n_19_1 1k
Rh_19_1 n_19_1 n_19_2 1k
Rh_19_2 n_19_2 n_19_3 1k
Rh_19_3 n_19_3 n_19_4 1k
Rh_19_4 n_19_4 n_19_5 1k
Rh_19_5 n_19_5 n_19_6 1k
Rh_19_6 n_19_6 n_19_7 1k
Rh_19_7 n_19_7 n_19_8 1k
Rh_19_8 n_19_8 n_19_9 1k
Rh_19_9 n_19_9 n_19_10 1k
Rh_19_10 n_19_10 n_19_11 1k
Rh_19_11 n_19_11 n_19_12 1k
Rh_19_12 n_19_12 n_19_13 1k
Rh_19_13 n_19_13 n_19_14 1k
Rh_19_14 n_19_14 n_19_15 1k
Rh_19_15 n_19_15 n_19_16 1k
Rh_19_16 n_19_16 n_19_17 1k
Rh_19_17 n_19_17 n_19_18 1k
Rh_19_18 n_19_18 n_19_19 1k
Rh_19_19 n_19_19 n_19_20 1k
Rh_19_20 n_19_20 n_19_21 1k

* Row 20
Rh_20_0 n_20_0 n_20_1 1k
Rh_20_1 n_20_1 n_20_2 1k
Rh_20_2 n_20_2 n_20_3 1k
Rh_20_3 n_20_3 n_20_4 1k
Rh_20_4 n_20_4 n_20_5 1k
Rh_20_5 n_20_5 n_20_6 1k
Rh_20_6 n_20_6 n_20_7 1k
Rh_20_7 n_20_7 n_20_8 1k
Rh_20_8 n_20_8 n_20_9 1k
Rh_20_9 n_20_9 n_20_10 1k
Rh_20_10 n_20_10 n_20_11 1k
Rh_20_11 n_20_11 n_20_12 1k
Rh_20_12 n_20_12 n_20_13 1k
Rh_20_13 n_20_13 n_20_14 1k
Rh_20_14 n_20_14 n_20_15 1k
Rh_20_15 n_20_15 n_20_16 1k
Rh_20_16 n_20_16 n_20_17 1k
Rh_20_17 n_20_17 n_20_18 1k
Rh_20_18 n_20_18 n_20_19 1k
Rh_20_19 n_20_19 n_20_20 1k
Rh_20_20 n_20_20 n_20_21 1k

* Row 21
Rh_21_0 n_21_0 n_21_1 1k
Rh_21_1 n_21_1 n_21_2 1k
Rh_21_2 n_21_2 n_21_3 1k
Rh_21_3 n_21_3 n_21_4 1k
Rh_21_4 n_21_4 n_21_5 1k
Rh_21_5 n_21_5 n_21_6 1k
Rh_21_6 n_21_6 n_21_7 1k
Rh_21_7 n_21_7 n_21_8 1k
Rh_21_8 n_21_8 n_21_9 1k
Rh_21_9 n_21_9 n_21_10 1k
Rh_21_10 n_21_10 n_21_11 1k
Rh_21_11 n_21_11 n_21_12 1k
Rh_21_12 n_21_12 n_21_13 1k
Rh_21_13 n_21_13 n_21_14 1k
Rh_21_14 n_21_14 n_21_15 1k
Rh_21_15 n_21_15 n_21_16 1k
Rh_21_16 n_21_16 n_21_17 1k
Rh_21_17 n_21_17 n_21_18 1k
Rh_21_18 n_21_18 n_21_19 1k
Rh_21_19 n_21_19 n_21_20 1k
Rh_21_20 n_21_20 n_21_21 1k

* Vertical resistors (Column 0)
Rv_0_0 n_0_0 n_1_0 1k
Rv_1_0 n_1_0 n_2_0 1k
Rv_2_0 n_2_0 n_3_0 1k
Rv_3_0 n_3_0 n_4_0 1k
Rv_4_0 n_4_0 n_5_0 1k
Rv_5_0 n_5_0 n_6_0 1k
Rv_6_0 n_6_0 n_7_0 1k
Rv_7_0 n_7_0 n_8_0 1k
Rv_8_0 n_8_0 n_9_0 1k
Rv_9_0 n_9_0 n_10_0 1k
Rv_10_0 n_10_0 n_11_0 1k
Rv_11_0 n_11_0 n_12_0 1k
Rv_12_0 n_12_0 n_13_0 1k
Rv_13_0 n_13_0 n_14_0 1k
Rv_14_0 n_14_0 n_15_0 1k
Rv_15_0 n_15_0 n_16_0 1k
Rv_16_0 n_16_0 n_17_0 1k
Rv_17_0 n_17_0 n_18_0 1k
Rv_18_0 n_18_0 n_19_0 1k
Rv_19_0 n_19_0 n_20_0 1k
Rv_20_0 n_20_0 n_21_0 1k

* Vertical resistors (Column 1)
Rv_0_1 n_0_1 n_1_1 1k
Rv_1_1 n_1_1 n_2_1 1k
Rv_2_1 n_2_1 n_3_1 1k
Rv_3_1 n_3_1 n_4_1 1k
Rv_4_1 n_4_1 n_5_1 1k
Rv_5_1 n_5_1 n_6_1 1k
Rv_6_1 n_6_1 n_7_1 1k
Rv_7_1 n_7_1 n_8_1 1k
Rv_8_1 n_8_1 n_9_1 1k
Rv_9_1 n_9_1 n_10_1 1k
Rv_10_1 n_10_1 n_11_1 1k
Rv_11_1 n_11_1 n_12_1 1k
Rv_12_1 n_12_1 n_13_1 1k
Rv_13_1 n_13_1 n_14_1 1k
Rv_14_1 n_14_1 n_15_1 1k
Rv_15_1 n_15_1 n_16_1 1k
Rv_16_1 n_16_1 n_17_1 1k
Rv_17_1 n_17_1 n_18_1 1k
Rv_18_1 n_18_1 n_19_1 1k
Rv_19_1 n_19_1 n_20_1 1k
Rv_20_1 n_20_1 n_21_1 1k

* Vertical resistors (Column 2)
Rv_0_2 n_0_2 n_1_2 1k
Rv_1_2 n_1_2 n_2_2 1k
Rv_2_2 n_2_2 n_3_2 1k
Rv_3_2 n_3_2 n_4_2 1k
Rv_4_2 n_4_2 n_5_2 1k
Rv_5_2 n_5_2 n_6_2 1k
Rv_6_2 n_6_2 n_7_2 1k
Rv_7_2 n_7_2 n_8_2 1k
Rv_8_2 n_8_2 n_9_2 1k
Rv_9_2 n_9_2 n_10_2 1k
Rv_10_2 n_10_2 n_11_2 1k
Rv_11_2 n_11_2 n_12_2 1k
Rv_12_2 n_12_2 n_13_2 1k
Rv_13_2 n_13_2 n_14_2 1k
Rv_14_2 n_14_2 n_15_2 1k
Rv_15_2 n_15_2 n_16_2 1k
Rv_16_2 n_16_2 n_17_2 1k
Rv_17_2 n_17_2 n_18_2 1k
Rv_18_2 n_18_2 n_19_2 1k
Rv_19_2 n_19_2 n_20_2 1k
Rv_20_2 n_20_2 n_21_2 1k

* Vertical resistors (Column 3)
Rv_0_3 n_0_3 n_1_3 1k
Rv_1_3 n_1_3 n_2_3 1k
Rv_2_3 n_2_3 n_3_3 1k
Rv_3_3 n_3_3 n_4_3 1k
Rv_4_3 n_4_3 n_5_3 1k
Rv_5_3 n_5_3 n_6_3 1k
Rv_6_3 n_6_3 n_7_3 1k
Rv_7_3 n_7_3 n_8_3 1k
Rv_8_3 n_8_3 n_9_3 1k
Rv_9_3 n_9_3 n_10_3 1k
Rv_10_3 n_10_3 n_11_3 1k
Rv_11_3 n_11_3 n_12_3 1k
Rv_12_3 n_12_3 n_13_3 1k
Rv_13_3 n_13_3 n_14_3 1k
Rv_14_3 n_14_3 n_15_3 1k
Rv_15_3 n_15_3 n_16_3 1k
Rv_16_3 n_16_3 n_17_3 1k
Rv_17_3 n_17_3 n_18_3 1k
Rv_18_3 n_18_3 n_19_3 1k
Rv_19_3 n_19_3 n_20_3 1k
Rv_20_3 n_20_3 n_21_3 1k

* Vertical resistors (Column 4)
Rv_0_4 n_0_4 n_1_4 1k
Rv_1_4 n_1_4 n_2_4 1k
Rv_2_4 n_2_4 n_3_4 1k
Rv_3_4 n_3_4 n_4_4 1k
Rv_4_4 n_4_4 n_5_4 1k
Rv_5_4 n_5_4 n_6_4 1k
Rv_6_4 n_6_4 n_7_4 1k
Rv_7_4 n_7_4 n_8_4 1k
Rv_8_4 n_8_4 n_9_4 1k
Rv_9_4 n_9_4 n_10_4 1k
Rv_10_4 n_10_4 n_11_4 1k
Rv_11_4 n_11_4 n_12_4 1k
Rv_12_4 n_12_4 n_13_4 1k
Rv_13_4 n_13_4 n_14_4 1k
Rv_14_4 n_14_4 n_15_4 1k
Rv_15_4 n_15_4 n_16_4 1k
Rv_16_4 n_16_4 n_17_4 1k
Rv_17_4 n_17_4 n_18_4 1k
Rv_18_4 n_18_4 n_19_4 1k
Rv_19_4 n_19_4 n_20_4 1k
Rv_20_4 n_20_4 n_21_4 1k

* Vertical resistors (Column 5)
Rv_0_5 n_0_5 n_1_5 1k
Rv_1_5 n_1_5 n_2_5 1k
Rv_2_5 n_2_5 n_3_5 1k
Rv_3_5 n_3_5 n_4_5 1k
Rv_4_5 n_4_5 n_5_5 1k
Rv_5_5 n_5_5 n_6_5 1k
Rv_6_5 n_6_5 n_7_5 1k
Rv_7_5 n_7_5 n_8_5 1k
Rv_8_5 n_8_5 n_9_5 1k
Rv_9_5 n_9_5 n_10_5 1k
Rv_10_5 n_10_5 n_11_5 1k
Rv_11_5 n_11_5 n_12_5 1k
Rv_12_5 n_12_5 n_13_5 1k
Rv_13_5 n_13_5 n_14_5 1k
Rv_14_5 n_14_5 n_15_5 1k
Rv_15_5 n_15_5 n_16_5 1k
Rv_16_5 n_16_5 n_17_5 1k
Rv_17_5 n_17_5 n_18_5 1k
Rv_18_5 n_18_5 n_19_5 1k
Rv_19_5 n_19_5 n_20_5 1k
Rv_20_5 n_20_5 n_21_5 1k

* Vertical resistors (Column 6)
Rv_0_6 n_0_6 n_1_6 1k
Rv_1_6 n_1_6 n_2_6 1k
Rv_2_6 n_2_6 n_3_6 1k
Rv_3_6 n_3_6 n_4_6 1k
Rv_4_6 n_4_6 n_5_6 1k
Rv_5_6 n_5_6 n_6_6 1k
Rv_6_6 n_6_6 n_7_6 1k
Rv_7_6 n_7_6 n_8_6 1k
Rv_8_6 n_8_6 n_9_6 1k
Rv_9_6 n_9_6 n_10_6 1k
Rv_10_6 n_10_6 n_11_6 1k
Rv_11_6 n_11_6 n_12_6 1k
Rv_12_6 n_12_6 n_13_6 1k
Rv_13_6 n_13_6 n_14_6 1k
Rv_14_6 n_14_6 n_15_6 1k
Rv_15_6 n_15_6 n_16_6 1k
Rv_16_6 n_16_6 n_17_6 1k
Rv_17_6 n_17_6 n_18_6 1k
Rv_18_6 n_18_6 n_19_6 1k
Rv_19_6 n_19_6 n_20_6 1k
Rv_20_6 n_20_6 n_21_6 1k

* Vertical resistors (Column 7)
Rv_0_7 n_0_7 n_1_7 1k
Rv_1_7 n_1_7 n_2_7 1k
Rv_2_7 n_2_7 n_3_7 1k
Rv_3_7 n_3_7 n_4_7 1k
Rv_4_7 n_4_7 n_5_7 1k
Rv_5_7 n_5_7 n_6_7 1k
Rv_6_7 n_6_7 n_7_7 1k
Rv_7_7 n_7_7 n_8_7 1k
Rv_8_7 n_8_7 n_9_7 1k
Rv_9_7 n_9_7 n_10_7 1k
Rv_10_7 n_10_7 n_11_7 1k
Rv_11_7 n_11_7 n_12_7 1k
Rv_12_7 n_12_7 n_13_7 1k
Rv_13_7 n_13_7 n_14_7 1k
Rv_14_7 n_14_7 n_15_7 1k
Rv_15_7 n_15_7 n_16_7 1k
Rv_16_7 n_16_7 n_17_7 1k
Rv_17_7 n_17_7 n_18_7 1k
Rv_18_7 n_18_7 n_19_7 1k
Rv_19_7 n_19_7 n_20_7 1k
Rv_20_7 n_20_7 n_21_7 1k

* Vertical resistors (Column 8)
Rv_0_8 n_0_8 n_1_8 1k
Rv_1_8 n_1_8 n_2_8 1k
Rv_2_8 n_2_8 n_3_8 1k
Rv_3_8 n_3_8 n_4_8 1k
Rv_4_8 n_4_8 n_5_8 1k
Rv_5_8 n_5_8 n_6_8 1k
Rv_6_8 n_6_8 n_7_8 1k
Rv_7_8 n_7_8 n_8_8 1k
Rv_8_8 n_8_8 n_9_8 1k
Rv_9_8 n_9_8 n_10_8 1k
Rv_10_8 n_10_8 n_11_8 1k
Rv_11_8 n_11_8 n_12_8 1k
Rv_12_8 n_12_8 n_13_8 1k
Rv_13_8 n_13_8 n_14_8 1k
Rv_14_8 n_14_8 n_15_8 1k
Rv_15_8 n_15_8 n_16_8 1k
Rv_16_8 n_16_8 n_17_8 1k
Rv_17_8 n_17_8 n_18_8 1k
Rv_18_8 n_18_8 n_19_8 1k
Rv_19_8 n_19_8 n_20_8 1k
Rv_20_8 n_20_8 n_21_8 1k

* Vertical resistors (Column 9)
Rv_0_9 n_0_9 n_1_9 1k
Rv_1_9 n_1_9 n_2_9 1k
Rv_2_9 n_2_9 n_3_9 1k
Rv_3_9 n_3_9 n_4_9 1k
Rv_4_9 n_4_9 n_5_9 1k
Rv_5_9 n_5_9 n_6_9 1k
Rv_6_9 n_6_9 n_7_9 1k
Rv_7_9 n_7_9 n_8_9 1k
Rv_8_9 n_8_9 n_9_9 1k
Rv_9_9 n_9_9 n_10_9 1k
Rv_10_9 n_10_9 n_11_9 1k
Rv_11_9 n_11_9 n_12_9 1k
Rv_12_9 n_12_9 n_13_9 1k
Rv_13_9 n_13_9 n_14_9 1k
Rv_14_9 n_14_9 n_15_9 1k
Rv_15_9 n_15_9 n_16_9 1k
Rv_16_9 n_16_9 n_17_9 1k
Rv_17_9 n_17_9 n_18_9 1k
Rv_18_9 n_18_9 n_19_9 1k
Rv_19_9 n_19_9 n_20_9 1k
Rv_20_9 n_20_9 n_21_9 1k

* Vertical resistors (Column 10)
Rv_0_10 n_0_10 n_1_10 1k
Rv_1_10 n_1_10 n_2_10 1k
Rv_2_10 n_2_10 n_3_10 1k
Rv_3_10 n_3_10 n_4_10 1k
Rv_4_10 n_4_10 n_5_10 1k
Rv_5_10 n_5_10 n_6_10 1k
Rv_6_10 n_6_10 n_7_10 1k
Rv_7_10 n_7_10 n_8_10 1k
Rv_8_10 n_8_10 n_9_10 1k
Rv_9_10 n_9_10 n_10_10 1k
Rv_10_10 n_10_10 n_11_10 1k
Rv_11_10 n_11_10 n_12_10 1k
Rv_12_10 n_12_10 n_13_10 1k
Rv_13_10 n_13_10 n_14_10 1k
Rv_14_10 n_14_10 n_15_10 1k
Rv_15_10 n_15_10 n_16_10 1k
Rv_16_10 n_16_10 n_17_10 1k
Rv_17_10 n_17_10 n_18_10 1k
Rv_18_10 n_18_10 n_19_10 1k
Rv_19_10 n_19_10 n_20_10 1k
Rv_20_10 n_20_10 n_21_10 1k

* Vertical resistors (Column 11)
Rv_0_11 n_0_11 n_1_11 1k
Rv_1_11 n_1_11 n_2_11 1k
Rv_2_11 n_2_11 n_3_11 1k
Rv_3_11 n_3_11 n_4_11 1k
Rv_4_11 n_4_11 n_5_11 1k
Rv_5_11 n_5_11 n_6_11 1k
Rv_6_11 n_6_11 n_7_11 1k
Rv_7_11 n_7_11 n_8_11 1k
Rv_8_11 n_8_11 n_9_11 1k
Rv_9_11 n_9_11 n_10_11 1k
Rv_10_11 n_10_11 n_11_11 1k
Rv_11_11 n_11_11 n_12_11 1k
Rv_12_11 n_12_11 n_13_11 1k
Rv_13_11 n_13_11 n_14_11 1k
Rv_14_11 n_14_11 n_15_11 1k
Rv_15_11 n_15_11 n_16_11 1k
Rv_16_11 n_16_11 n_17_11 1k
Rv_17_11 n_17_11 n_18_11 1k
Rv_18_11 n_18_11 n_19_11 1k
Rv_19_11 n_19_11 n_20_11 1k
Rv_20_11 n_20_11 n_21_11 1k

* Vertical resistors (Column 12)
Rv_0_12 n_0_12 n_1_12 1k
Rv_1_12 n_1_12 n_2_12 1k
Rv_2_12 n_2_12 n_3_12 1k
Rv_3_12 n_3_12 n_4_12 1k
Rv_4_12 n_4_12 n_5_12 1k
Rv_5_12 n_5_12 n_6_12 1k
Rv_6_12 n_6_12 n_7_12 1k
Rv_7_12 n_7_12 n_8_12 1k
Rv_8_12 n_8_12 n_9_12 1k
Rv_9_12 n_9_12 n_10_12 1k
Rv_10_12 n_10_12 n_11_12 1k
Rv_11_12 n_11_12 n_12_12 1k
Rv_12_12 n_12_12 n_13_12 1k
Rv_13_12 n_13_12 n_14_12 1k
Rv_14_12 n_14_12 n_15_12 1k
Rv_15_12 n_15_12 n_16_12 1k
Rv_16_12 n_16_12 n_17_12 1k
Rv_17_12 n_17_12 n_18_12 1k
Rv_18_12 n_18_12 n_19_12 1k
Rv_19_12 n_19_12 n_20_12 1k
Rv_20_12 n_20_12 n_21_12 1k

* Vertical resistors (Column 13)
Rv_0_13 n_0_13 n_1_13 1k
Rv_1_13 n_1_13 n_2_13 1k
Rv_2_13 n_2_13 n_3_13 1k
Rv_3_13 n_3_13 n_4_13 1k
Rv_4_13 n_4_13 n_5_13 1k
Rv_5_13 n_5_13 n_6_13 1k
Rv_6_13 n_6_13 n_7_13 1k
Rv_7_13 n_7_13 n_8_13 1k
Rv_8_13 n_8_13 n_9_13 1k
Rv_9_13 n_9_13 n_10_13 1k
Rv_10_13 n_10_13 n_11_13 1k
Rv_11_13 n_11_13 n_12_13 1k
Rv_12_13 n_12_13 n_13_13 1k
Rv_13_13 n_13_13 n_14_13 1k
Rv_14_13 n_14_13 n_15_13 1k
Rv_15_13 n_15_13 n_16_13 1k
Rv_16_13 n_16_13 n_17_13 1k
Rv_17_13 n_17_13 n_18_13 1k
Rv_18_13 n_18_13 n_19_13 1k
Rv_19_13 n_19_13 n_20_13 1k
Rv_20_13 n_20_13 n_21_13 1k

* Vertical resistors (Column 14)
Rv_0_14 n_0_14 n_1_14 1k
Rv_1_14 n_1_14 n_2_14 1k
Rv_2_14 n_2_14 n_3_14 1k
Rv_3_14 n_3_14 n_4_14 1k
Rv_4_14 n_4_14 n_5_14 1k
Rv_5_14 n_5_14 n_6_14 1k
Rv_6_14 n_6_14 n_7_14 1k
Rv_7_14 n_7_14 n_8_14 1k
Rv_8_14 n_8_14 n_9_14 1k
Rv_9_14 n_9_14 n_10_14 1k
Rv_10_14 n_10_14 n_11_14 1k
Rv_11_14 n_11_14 n_12_14 1k
Rv_12_14 n_12_14 n_13_14 1k
Rv_13_14 n_13_14 n_14_14 1k
Rv_14_14 n_14_14 n_15_14 1k
Rv_15_14 n_15_14 n_16_14 1k
Rv_16_14 n_16_14 n_17_14 1k
Rv_17_14 n_17_14 n_18_14 1k
Rv_18_14 n_18_14 n_19_14 1k
Rv_19_14 n_19_14 n_20_14 1k
Rv_20_14 n_20_14 n_21_14 1k

* Vertical resistors (Column 15)
Rv_0_15 n_0_15 n_1_15 1k
Rv_1_15 n_1_15 n_2_15 1k
Rv_2_15 n_2_15 n_3_15 1k
Rv_3_15 n_3_15 n_4_15 1k
Rv_4_15 n_4_15 n_5_15 1k
Rv_5_15 n_5_15 n_6_15 1k
Rv_6_15 n_6_15 n_7_15 1k
Rv_7_15 n_7_15 n_8_15 1k
Rv_8_15 n_8_15 n_9_15 1k
Rv_9_15 n_9_15 n_10_15 1k
Rv_10_15 n_10_15 n_11_15 1k
Rv_11_15 n_11_15 n_12_15 1k
Rv_12_15 n_12_15 n_13_15 1k
Rv_13_15 n_13_15 n_14_15 1k
Rv_14_15 n_14_15 n_15_15 1k
Rv_15_15 n_15_15 n_16_15 1k
Rv_16_15 n_16_15 n_17_15 1k
Rv_17_15 n_17_15 n_18_15 1k
Rv_18_15 n_18_15 n_19_15 1k
Rv_19_15 n_19_15 n_20_15 1k
Rv_20_15 n_20_15 n_21_15 1k

* Vertical resistors (Column 16)
Rv_0_16 n_0_16 n_1_16 1k
Rv_1_16 n_1_16 n_2_16 1k
Rv_2_16 n_2_16 n_3_16 1k
Rv_3_16 n_3_16 n_4_16 1k
Rv_4_16 n_4_16 n_5_16 1k
Rv_5_16 n_5_16 n_6_16 1k
Rv_6_16 n_6_16 n_7_16 1k
Rv_7_16 n_7_16 n_8_16 1k
Rv_8_16 n_8_16 n_9_16 1k
Rv_9_16 n_9_16 n_10_16 1k
Rv_10_16 n_10_16 n_11_16 1k
Rv_11_16 n_11_16 n_12_16 1k
Rv_12_16 n_12_16 n_13_16 1k
Rv_13_16 n_13_16 n_14_16 1k
Rv_14_16 n_14_16 n_15_16 1k
Rv_15_16 n_15_16 n_16_16 1k
Rv_16_16 n_16_16 n_17_16 1k
Rv_17_16 n_17_16 n_18_16 1k
Rv_18_16 n_18_16 n_19_16 1k
Rv_19_16 n_19_16 n_20_16 1k
Rv_20_16 n_20_16 n_21_16 1k

* Vertical resistors (Column 17)
Rv_0_17 n_0_17 n_1_17 1k
Rv_1_17 n_1_17 n_2_17 1k
Rv_2_17 n_2_17 n_3_17 1k
Rv_3_17 n_3_17 n_4_17 1k
Rv_4_17 n_4_17 n_5_17 1k
Rv_5_17 n_5_17 n_6_17 1k
Rv_6_17 n_6_17 n_7_17 1k
Rv_7_17 n_7_17 n_8_17 1k
Rv_8_17 n_8_17 n_9_17 1k
Rv_9_17 n_9_17 n_10_17 1k
Rv_10_17 n_10_17 n_11_17 1k
Rv_11_17 n_11_17 n_12_17 1k
Rv_12_17 n_12_17 n_13_17 1k
Rv_13_17 n_13_17 n_14_17 1k
Rv_14_17 n_14_17 n_15_17 1k
Rv_15_17 n_15_17 n_16_17 1k
Rv_16_17 n_16_17 n_17_17 1k
Rv_17_17 n_17_17 n_18_17 1k
Rv_18_17 n_18_17 n_19_17 1k
Rv_19_17 n_19_17 n_20_17 1k
Rv_20_17 n_20_17 n_21_17 1k

* Vertical resistors (Column 18)
Rv_0_18 n_0_18 n_1_18 1k
Rv_1_18 n_1_18 n_2_18 1k
Rv_2_18 n_2_18 n_3_18 1k
Rv_3_18 n_3_18 n_4_18 1k
Rv_4_18 n_4_18 n_5_18 1k
Rv_5_18 n_5_18 n_6_18 1k
Rv_6_18 n_6_18 n_7_18 1k
Rv_7_18 n_7_18 n_8_18 1k
Rv_8_18 n_8_18 n_9_18 1k
Rv_9_18 n_9_18 n_10_18 1k
Rv_10_18 n_10_18 n_11_18 1k
Rv_11_18 n_11_18 n_12_18 1k
Rv_12_18 n_12_18 n_13_18 1k
Rv_13_18 n_13_18 n_14_18 1k
Rv_14_18 n_14_18 n_15_18 1k
Rv_15_18 n_15_18 n_16_18 1k
Rv_16_18 n_16_18 n_17_18 1k
Rv_17_18 n_17_18 n_18_18 1k
Rv_18_18 n_18_18 n_19_18 1k
Rv_19_18 n_19_18 n_20_18 1k
Rv_20_18 n_20_18 n_21_18 1k

* Vertical resistors (Column 19)
Rv_0_19 n_0_19 n_1_19 1k
Rv_1_19 n_1_19 n_2_19 1k
Rv_2_19 n_2_19 n_3_19 1k
Rv_3_19 n_3_19 n_4_19 1k
Rv_4_19 n_4_19 n_5_19 1k
Rv_5_19 n_5_19 n_6_19 1k
Rv_6_19 n_6_19 n_7_19 1k
Rv_7_19 n_7_19 n_8_19 1k
Rv_8_19 n_8_19 n_9_19 1k
Rv_9_19 n_9_19 n_10_19 1k
Rv_10_19 n_10_19 n_11_19 1k
Rv_11_19 n_11_19 n_12_19 1k
Rv_12_19 n_12_19 n_13_19 1k
Rv_13_19 n_13_19 n_14_19 1k
Rv_14_19 n_14_19 n_15_19 1k
Rv_15_19 n_15_19 n_16_19 1k
Rv_16_19 n_16_19 n_17_19 1k
Rv_17_19 n_17_19 n_18_19 1k
Rv_18_19 n_18_19 n_19_19 1k
Rv_19_19 n_19_19 n_20_19 1k
Rv_20_19 n_20_19 n_21_19 1k

* Vertical resistors (Column 20)
Rv_0_20 n_0_20 n_1_20 1k
Rv_1_20 n_1_20 n_2_20 1k
Rv_2_20 n_2_20 n_3_20 1k
Rv_3_20 n_3_20 n_4_20 1k
Rv_4_20 n_4_20 n_5_20 1k
Rv_5_20 n_5_20 n_6_20 1k
Rv_6_20 n_6_20 n_7_20 1k
Rv_7_20 n_7_20 n_8_20 1k
Rv_8_20 n_8_20 n_9_20 1k
Rv_9_20 n_9_20 n_10_20 1k
Rv_10_20 n_10_20 n_11_20 1k
Rv_11_20 n_11_20 n_12_20 1k
Rv_12_20 n_12_20 n_13_20 1k
Rv_13_20 n_13_20 n_14_20 1k
Rv_14_20 n_14_20 n_15_20 1k
Rv_15_20 n_15_20 n_16_20 1k
Rv_16_20 n_16_20 n_17_20 1k
Rv_17_20 n_17_20 n_18_20 1k
Rv_18_20 n_18_20 n_19_20 1k
Rv_19_20 n_19_20 n_20_20 1k
Rv_20_20 n_20_20 n_21_20 1k

* Vertical resistors (Column 21)
Rv_0_21 n_0_21 n_1_21 1k
Rv_1_21 n_1_21 n_2_21 1k
Rv_2_21 n_2_21 n_3_21 1k
Rv_3_21 n_3_21 n_4_21 1k
Rv_4_21 n_4_21 n_5_21 1k
Rv_5_21 n_5_21 n_6_21 1k
Rv_6_21 n_6_21 n_7_21 1k
Rv_7_21 n_7_21 n_8_21 1k
Rv_8_21 n_8_21 n_9_21 1k
Rv_9_21 n_9_21 n_10_21 1k
Rv_10_21 n_10_21 n_11_21 1k
Rv_11_21 n_11_21 n_12_21 1k
Rv_12_21 n_12_21 n_13_21 1k
Rv_13_21 n_13_21 n_14_21 1k
Rv_14_21 n_14_21 n_15_21 1k
Rv_15_21 n_15_21 n_16_21 1k
Rv_16_21 n_16_21 n_17_21 1k
Rv_17_21 n_17_21 n_18_21 1k
Rv_18_21 n_18_21 n_19_21 1k
Rv_19_21 n_19_21 n_20_21 1k
Rv_20_21 n_20_21 n_21_21 1k

* Load resistor at bottom-right corner
Rload n_21_21 0 1k

.op
.control
op
print all > resistor_mesh_22x22_dc_raw.txt
.endc
.end
