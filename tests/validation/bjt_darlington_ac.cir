* BJT Darlington Pair Amplifier AC Analysis
* Q1 drives Q2, emitters connected

.model Q2N2222 NPN BF=100 IS=1e-14

* Power supply
Vcc vcc 0 DC 12

* Input signal (AC only)
Vin in 0 DC 0 AC 0.01

* Input coupling
Cin in base1 10u

* Bias network
R1 vcc base1 100k
R2 base1 0 22k

* Darlington pair: Q1 drives Q2
* Q1: collector to Vcc, emitter to Q2 base
Q1 vcc base1 e1 Q2N2222
* Q2: base from Q1 emitter
Q2 c2 e1 e2 Q2N2222

* Collector resistor (for Q2)
Rc vcc c2 4.7k

* Emitter resistor with bypass
Re e2 0 1k
Ce e2 0 100u

* Output
Cout c2 out 10u
Rload out 0 10k

.ac dec 20 10 1000000

.control
ac dec 20 10 1000000
wrdata bjt_darlington_ac_ngspice.dat v(out)
.endc
.end
