* RLC Band-Pass Filter AC Analysis for validation
* Circuit: V(1V AC) -> R(100) -> L(10m) -> C(1u) -> Rload(1k) -> GND
* Center frequency: f0 = 1/(2*pi*sqrt(L*C)) = 1591.5 Hz

V1 in 0 DC 0 AC 1
R1 in n1 100
L1 n1 n2 10m
C1 n2 out 1u
Rload out 0 1k

.ac dec 20 100 100k
.control
run
wrdata rlc_bandpass_ac_ngspice.csv v(out)
.endc
.end
