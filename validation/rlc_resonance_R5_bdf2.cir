* RLC step response (R=5Ω, moderate Q) with Gear2/BDF2 reference
V1 in 0 5
R1 in n1 5
L1 n1 out 1m
C1 out 0 10u
.option method=gear
.tran 1e-7 1e-3 uic
.control
  run
  set filetype=ascii
  wrdata validation/rlc_resonance_R5_bdf2_ngspice_ref.txt v(out)
  quit
.endc
.end
