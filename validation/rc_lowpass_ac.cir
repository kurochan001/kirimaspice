* RC Low-Pass Filter - AC Analysis Test
* Cutoff frequency: fc = 1/(2*pi*R*C) = 159.15 Hz

Vin in 0 DC 0 AC 1
R1 in out 1k
C1 out 0 1u

.ac dec 20 10 10k

.control
* Run AC analysis
ac dec 20 10 10k

* Write AC analysis results to CSV file
set wr_singlescale
set wr_vecnames
option numdgt=7
* Output real and imaginary parts of v(out)
wrdata rc_lowpass_ac_ngspice.csv Re(v(out)) Im(v(out))

quit
.endc

.end
