Darlington Pair BJT Amplifier AC Analysis
* High current gain configuration with two BJTs

* Power supply
Vcc vcc 0 DC 12

* Input signal (AC only)
Vin in 0 DC 0 AC 0.01

* Input coupling
Cin in base1 10u

* Bias network
R1 vcc base1 100k
R2 base1 0 22k

* Darlington pair: Q1 drives Q2
* Q1 collector to Vcc
Q1 vcc base1 e1 QNL
* Q2 emitter connected to Q1 emitter
Q2 c2 e1 e2 QNL

* Collector resistor (for Q2)
Rc vcc c2 4.7k

* Emitter resistor with bypass
Re e2 0 1k
Ce e2 0 100u

* Output coupling
Cout c2 out 10u
* Load resistor
Rload out 0 10k

* BJT model (match kirimaspice defaults: β=100, IS=1e-14)
.model QNL NPN(BF=100 IS=1e-14)

* AC analysis: 10 Hz to 1 MHz, 20 points per decade
.ac dec 20 10 1Meg

.control
* Run AC analysis
ac dec 20 10 1Meg

* Write AC analysis results to CSV file
set wr_singlescale
set wr_vecnames
option numdgt=7
* Output real and imaginary parts of v(out)
wrdata bjt_darlington_ac_ngspice.csv Re(v(out)) Im(v(out))

quit
.endc

.end
