RLC Band-Stop Filter (Notch Filter) AC Analysis
* Center frequency: f0 = 1/(2*pi*sqrt(LC)) = 1591.5 Hz
* Parallel resonance creates high impedance at f0, blocking that frequency

* Input voltage source (AC magnitude = 1V)
Vin in 0 DC 0 AC 1

* Band-stop filter: V -> R1 -> out -> R_load -> GND
*                              |
*                         [series: L-C] (trap)
*                              |
*                             GND
* Series LC trap creates low impedance (short) at resonance to GND
R1 in out 1k
L1 out trap 10m
C1 trap 0 1u
Rload out 0 1k

* AC analysis: 100 Hz to 100 kHz, 20 points per decade
.ac dec 20 100 100k

.control
* Run AC analysis
ac dec 20 100 100k

* Write AC analysis results to CSV file
set wr_singlescale
set wr_vecnames
option numdgt=7
* Output real and imaginary parts of v(out)
wrdata rlc_bandstop_ac_ngspice.csv Re(v(out)) Im(v(out))

quit
.endc

.end
