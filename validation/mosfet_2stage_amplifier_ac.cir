2-Stage Common-Source MOSFET Amplifier AC Analysis
* The circuit that MOSFET2StageAmplifierValidation builds in
* tests/unit/test_multistage_amplifier_ac_validation.cpp: each gate is
* biased by a divider from VDD, so that both transistors conduct.
* mosfet_2stage_amplifier_ac_ngspice.csv was written by ngspice-45.2 from
* this file (ngspice -b mosfet_2stage_amplifier_ac.cir).

* Power supply
VDD vdd 0 DC 10

* Input signal (AC only)
Vin in 0 DC 0 AC 0.01

* Stage 1: common-source amplifier with divider bias
Cin in gate1 10u
Rg1a vdd gate1 1Meg
Rg1b gate1 0 470k
Rd1 vdd d1 10k
Rs1 s1 0 2k
Cs1 s1 0 100u
M1 d1 gate1 s1 s1 MNL W=10u L=1u

* Stage 2: common-source amplifier with divider bias
Cc d1 gate2 10u
Rg2a vdd gate2 1Meg
Rg2b gate2 0 470k
Rd2 vdd d2 10k
Rs2 s2 0 2k
Cs2 s2 0 100u
M2 d2 gate2 s2 s2 MNL W=10u L=1u

* Output coupling and load
Cout d2 out 10u
Rload out 0 10k

* MOSFET model (Level 1)
.model MNL NMOS(LEVEL=1 KP=2e-5 VTO=0.7 LAMBDA=0)

* AC analysis: 10 Hz to 1 MHz, 20 points per decade
.ac dec 20 10 1Meg

.control
ac dec 20 10 1Meg
set wr_singlescale
set wr_vecnames
option numdgt=7
wrdata mosfet_2stage_amplifier_ac_ngspice.csv Re(v(out)) Im(v(out))
quit
.endc

.end
