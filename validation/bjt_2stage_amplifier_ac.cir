2-Stage Common-Emitter BJT Amplifier AC Analysis
* Two-stage cascaded amplifier for high gain

* Power supply
Vcc vcc 0 DC 12

* Input signal (AC only)
Vin in 0 DC 0 AC 0.01

* Stage 1: Common-emitter amplifier
* Bias network for Q1
R1_1 vcc base1 100k
R2_1 base1 0 22k
* Input coupling
Cin in base1 10u
* Collector resistor
Rc1 vcc c1 4.7k
* Emitter resistor with bypass
Re1 e1 0 1k
Ce1 e1 0 100u
* BJT Q1 (NPN)
Q1 c1 base1 e1 QNL

* Stage 2: Common-emitter amplifier
* Coupling capacitor between stages
Cc c1 base2 10u
* Bias network for Q2
R1_2 vcc base2 100k
R2_2 base2 0 22k
* Collector resistor
Rc2 vcc c2 4.7k
* Emitter resistor with bypass
Re2 e2 0 1k
Ce2 e2 0 100u
* BJT Q2 (NPN)
Q2 c2 base2 e2 QNL

* Output coupling
Cout c2 out 10u
* Load resistor
Rload out 0 10k

* BJT model (match kirimaspice defaults: β=100, IS=1e-14)
.model QNL NPN(BF=100 IS=1e-14)

* AC analysis: 10 Hz to 1 MHz, 20 points per decade
.ac dec 20 10 1Meg

.control
* Run AC analysis
ac dec 20 10 1Meg

* Write AC analysis results to CSV file
set wr_singlescale
set wr_vecnames
option numdgt=7
* Output real and imaginary parts of v(out)
wrdata bjt_2stage_amplifier_ac_ngspice.csv Re(v(out)) Im(v(out))

quit
.endc

.end
